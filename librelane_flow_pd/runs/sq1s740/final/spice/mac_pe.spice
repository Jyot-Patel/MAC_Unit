* NGSPICE file created from mac_pe.ext - technology: sky130A

* Black-box entry subcircuit for sky130_fd_sc_hd__fill_2 abstract view
.subckt sky130_fd_sc_hd__fill_2 VGND VNB VPB VPWR
.ends

* Black-box entry subcircuit for sky130_fd_sc_hd__decap_3 abstract view
.subckt sky130_fd_sc_hd__decap_3 VGND VNB VPB VPWR
.ends

* Black-box entry subcircuit for sky130_fd_sc_hd__fill_1 abstract view
.subckt sky130_fd_sc_hd__fill_1 VGND VNB VPB VPWR
.ends

* Black-box entry subcircuit for sky130_fd_sc_hd__tapvpwrvgnd_1 abstract view
.subckt sky130_fd_sc_hd__tapvpwrvgnd_1 VGND VPWR
.ends

* Black-box entry subcircuit for sky130_fd_sc_hd__dfrtp_2 abstract view
.subckt sky130_fd_sc_hd__dfrtp_2 CLK D RESET_B VGND VNB VPB VPWR Q
.ends

* Black-box entry subcircuit for sky130_fd_sc_hd__nand4_2 abstract view
.subckt sky130_fd_sc_hd__nand4_2 A B C D VGND VNB VPB VPWR Y
.ends

* Black-box entry subcircuit for sky130_fd_sc_hd__nand2_2 abstract view
.subckt sky130_fd_sc_hd__nand2_2 A B VGND VNB VPB VPWR Y
.ends

* Black-box entry subcircuit for sky130_fd_sc_hd__a211o_2 abstract view
.subckt sky130_fd_sc_hd__a211o_2 A1 A2 B1 C1 VGND VNB VPB VPWR X
.ends

* Black-box entry subcircuit for sky130_fd_sc_hd__a2bb2o_2 abstract view
.subckt sky130_fd_sc_hd__a2bb2o_2 A1_N A2_N B1 B2 VGND VNB VPB VPWR X
.ends

* Black-box entry subcircuit for sky130_fd_sc_hd__o2111ai_2 abstract view
.subckt sky130_fd_sc_hd__o2111ai_2 A1 A2 B1 C1 D1 VGND VNB VPB VPWR Y
.ends

* Black-box entry subcircuit for sky130_fd_sc_hd__and2_4 abstract view
.subckt sky130_fd_sc_hd__and2_4 A B VGND VNB VPB VPWR X
.ends

* Black-box entry subcircuit for sky130_fd_sc_hd__inv_2 abstract view
.subckt sky130_fd_sc_hd__inv_2 A VGND VNB VPB VPWR Y
.ends

* Black-box entry subcircuit for sky130_fd_sc_hd__o2111ai_4 abstract view
.subckt sky130_fd_sc_hd__o2111ai_4 A1 A2 B1 C1 D1 VGND VNB VPB VPWR Y
.ends

* Black-box entry subcircuit for sky130_fd_sc_hd__a21oi_2 abstract view
.subckt sky130_fd_sc_hd__a21oi_2 A1 A2 B1 VGND VNB VPB VPWR Y
.ends

* Black-box entry subcircuit for sky130_fd_sc_hd__or3_2 abstract view
.subckt sky130_fd_sc_hd__or3_2 A B C VGND VNB VPB VPWR X
.ends

* Black-box entry subcircuit for sky130_fd_sc_hd__and2_2 abstract view
.subckt sky130_fd_sc_hd__and2_2 A B VGND VNB VPB VPWR X
.ends

* Black-box entry subcircuit for sky130_fd_sc_hd__or2_4 abstract view
.subckt sky130_fd_sc_hd__or2_4 A B VGND VNB VPB VPWR X
.ends

* Black-box entry subcircuit for sky130_fd_sc_hd__a22oi_2 abstract view
.subckt sky130_fd_sc_hd__a22oi_2 A1 A2 B1 B2 VGND VNB VPB VPWR Y
.ends

* Black-box entry subcircuit for sky130_fd_sc_hd__o211ai_2 abstract view
.subckt sky130_fd_sc_hd__o211ai_2 A1 A2 B1 C1 VGND VNB VPB VPWR Y
.ends

* Black-box entry subcircuit for sky130_fd_sc_hd__o21ai_2 abstract view
.subckt sky130_fd_sc_hd__o21ai_2 A1 A2 B1 VGND VNB VPB VPWR Y
.ends

* Black-box entry subcircuit for sky130_fd_sc_hd__buf_2 abstract view
.subckt sky130_fd_sc_hd__buf_2 A VGND VNB VPB VPWR X
.ends

* Black-box entry subcircuit for sky130_fd_sc_hd__clkdlybuf4s25_1 abstract view
.subckt sky130_fd_sc_hd__clkdlybuf4s25_1 A VGND VNB VPB VPWR X
.ends

* Black-box entry subcircuit for sky130_fd_sc_hd__clkbuf_16 abstract view
.subckt sky130_fd_sc_hd__clkbuf_16 A VGND VNB VPB VPWR X
.ends

* Black-box entry subcircuit for sky130_fd_sc_hd__nor2_2 abstract view
.subckt sky130_fd_sc_hd__nor2_2 A B VGND VNB VPB VPWR Y
.ends

* Black-box entry subcircuit for sky130_fd_sc_hd__clkbuf_1 abstract view
.subckt sky130_fd_sc_hd__clkbuf_1 A VGND VNB VPB VPWR X
.ends

* Black-box entry subcircuit for sky130_fd_sc_hd__and3_2 abstract view
.subckt sky130_fd_sc_hd__and3_2 A B C VGND VNB VPB VPWR X
.ends

* Black-box entry subcircuit for sky130_fd_sc_hd__buf_8 abstract view
.subckt sky130_fd_sc_hd__buf_8 A VGND VNB VPB VPWR X
.ends

* Black-box entry subcircuit for sky130_fd_sc_hd__a21o_2 abstract view
.subckt sky130_fd_sc_hd__a21o_2 A1 A2 B1 VGND VNB VPB VPWR X
.ends

* Black-box entry subcircuit for sky130_fd_sc_hd__and3_4 abstract view
.subckt sky130_fd_sc_hd__and3_4 A B C VGND VNB VPB VPWR X
.ends

* Black-box entry subcircuit for sky130_fd_sc_hd__o211a_2 abstract view
.subckt sky130_fd_sc_hd__o211a_2 A1 A2 B1 C1 VGND VNB VPB VPWR X
.ends

* Black-box entry subcircuit for sky130_fd_sc_hd__nand3_2 abstract view
.subckt sky130_fd_sc_hd__nand3_2 A B C VGND VNB VPB VPWR Y
.ends

* Black-box entry subcircuit for sky130_fd_sc_hd__buf_6 abstract view
.subckt sky130_fd_sc_hd__buf_6 A VGND VNB VPB VPWR X
.ends

* Black-box entry subcircuit for sky130_fd_sc_hd__and4_2 abstract view
.subckt sky130_fd_sc_hd__and4_2 A B C D VGND VNB VPB VPWR X
.ends

* Black-box entry subcircuit for sky130_fd_sc_hd__xor2_2 abstract view
.subckt sky130_fd_sc_hd__xor2_2 A B VGND VNB VPB VPWR X
.ends

* Black-box entry subcircuit for sky130_fd_sc_hd__nand4_4 abstract view
.subckt sky130_fd_sc_hd__nand4_4 A B C D VGND VNB VPB VPWR Y
.ends

* Black-box entry subcircuit for sky130_fd_sc_hd__a32o_2 abstract view
.subckt sky130_fd_sc_hd__a32o_2 A1 A2 A3 B1 B2 VGND VNB VPB VPWR X
.ends

* Black-box entry subcircuit for sky130_fd_sc_hd__o21a_4 abstract view
.subckt sky130_fd_sc_hd__o21a_4 A1 A2 B1 VGND VNB VPB VPWR X
.ends

* Black-box entry subcircuit for sky130_fd_sc_hd__o21bai_4 abstract view
.subckt sky130_fd_sc_hd__o21bai_4 A1 A2 B1_N VGND VNB VPB VPWR Y
.ends

* Black-box entry subcircuit for sky130_fd_sc_hd__o31ai_4 abstract view
.subckt sky130_fd_sc_hd__o31ai_4 A1 A2 A3 B1 VGND VNB VPB VPWR Y
.ends

* Black-box entry subcircuit for sky130_fd_sc_hd__nand2_4 abstract view
.subckt sky130_fd_sc_hd__nand2_4 A B VGND VNB VPB VPWR Y
.ends

* Black-box entry subcircuit for sky130_fd_sc_hd__a21oi_4 abstract view
.subckt sky130_fd_sc_hd__a21oi_4 A1 A2 B1 VGND VNB VPB VPWR Y
.ends

* Black-box entry subcircuit for sky130_fd_sc_hd__a21o_4 abstract view
.subckt sky130_fd_sc_hd__a21o_4 A1 A2 B1 VGND VNB VPB VPWR X
.ends

* Black-box entry subcircuit for sky130_fd_sc_hd__a211o_4 abstract view
.subckt sky130_fd_sc_hd__a211o_4 A1 A2 B1 C1 VGND VNB VPB VPWR X
.ends

* Black-box entry subcircuit for sky130_fd_sc_hd__buf_12 abstract view
.subckt sky130_fd_sc_hd__buf_12 A VGND VNB VPB VPWR X
.ends

* Black-box entry subcircuit for sky130_fd_sc_hd__o221ai_2 abstract view
.subckt sky130_fd_sc_hd__o221ai_2 A1 A2 B1 B2 C1 VGND VNB VPB VPWR Y
.ends

* Black-box entry subcircuit for sky130_fd_sc_hd__o21a_2 abstract view
.subckt sky130_fd_sc_hd__o21a_2 A1 A2 B1 VGND VNB VPB VPWR X
.ends

* Black-box entry subcircuit for sky130_fd_sc_hd__a41o_2 abstract view
.subckt sky130_fd_sc_hd__a41o_2 A1 A2 A3 A4 B1 VGND VNB VPB VPWR X
.ends

* Black-box entry subcircuit for sky130_fd_sc_hd__a22oi_4 abstract view
.subckt sky130_fd_sc_hd__a22oi_4 A1 A2 B1 B2 VGND VNB VPB VPWR Y
.ends

* Black-box entry subcircuit for sky130_fd_sc_hd__nand3_4 abstract view
.subckt sky130_fd_sc_hd__nand3_4 A B C VGND VNB VPB VPWR Y
.ends

* Black-box entry subcircuit for sky130_fd_sc_hd__o21ai_4 abstract view
.subckt sky130_fd_sc_hd__o21ai_4 A1 A2 B1 VGND VNB VPB VPWR Y
.ends

* Black-box entry subcircuit for sky130_fd_sc_hd__clkbuf_4 abstract view
.subckt sky130_fd_sc_hd__clkbuf_4 A VGND VNB VPB VPWR X
.ends

* Black-box entry subcircuit for sky130_fd_sc_hd__a22o_4 abstract view
.subckt sky130_fd_sc_hd__a22o_4 A1 A2 B1 B2 VGND VNB VPB VPWR X
.ends

* Black-box entry subcircuit for sky130_fd_sc_hd__nor3_2 abstract view
.subckt sky130_fd_sc_hd__nor3_2 A B C VGND VNB VPB VPWR Y
.ends

* Black-box entry subcircuit for sky130_fd_sc_hd__o22ai_2 abstract view
.subckt sky130_fd_sc_hd__o22ai_2 A1 A2 B1 B2 VGND VNB VPB VPWR Y
.ends

* Black-box entry subcircuit for sky130_fd_sc_hd__o31a_2 abstract view
.subckt sky130_fd_sc_hd__o31a_2 A1 A2 A3 B1 VGND VNB VPB VPWR X
.ends

* Black-box entry subcircuit for sky130_fd_sc_hd__o21bai_2 abstract view
.subckt sky130_fd_sc_hd__o21bai_2 A1 A2 B1_N VGND VNB VPB VPWR Y
.ends

* Black-box entry subcircuit for sky130_fd_sc_hd__a31o_2 abstract view
.subckt sky130_fd_sc_hd__a31o_2 A1 A2 A3 B1 VGND VNB VPB VPWR X
.ends

* Black-box entry subcircuit for sky130_fd_sc_hd__a22o_2 abstract view
.subckt sky130_fd_sc_hd__a22o_2 A1 A2 B1 B2 VGND VNB VPB VPWR X
.ends

* Black-box entry subcircuit for sky130_fd_sc_hd__and4_4 abstract view
.subckt sky130_fd_sc_hd__and4_4 A B C D VGND VNB VPB VPWR X
.ends

* Black-box entry subcircuit for sky130_fd_sc_hd__nand4b_4 abstract view
.subckt sky130_fd_sc_hd__nand4b_4 A_N B C D VGND VNB VPB VPWR Y
.ends

* Black-box entry subcircuit for sky130_fd_sc_hd__a21boi_4 abstract view
.subckt sky130_fd_sc_hd__a21boi_4 A1 A2 B1_N VGND VNB VPB VPWR Y
.ends

* Black-box entry subcircuit for sky130_fd_sc_hd__nand3b_2 abstract view
.subckt sky130_fd_sc_hd__nand3b_2 A_N B C VGND VNB VPB VPWR Y
.ends

* Black-box entry subcircuit for sky130_fd_sc_hd__o211a_4 abstract view
.subckt sky130_fd_sc_hd__o211a_4 A1 A2 B1 C1 VGND VNB VPB VPWR X
.ends

* Black-box entry subcircuit for sky130_fd_sc_hd__a2111oi_2 abstract view
.subckt sky130_fd_sc_hd__a2111oi_2 A1 A2 B1 C1 D1 VGND VNB VPB VPWR Y
.ends

* Black-box entry subcircuit for sky130_fd_sc_hd__a21boi_2 abstract view
.subckt sky130_fd_sc_hd__a21boi_2 A1 A2 B1_N VGND VNB VPB VPWR Y
.ends

* Black-box entry subcircuit for sky130_fd_sc_hd__o2bb2ai_2 abstract view
.subckt sky130_fd_sc_hd__o2bb2ai_2 A1_N A2_N B1 B2 VGND VNB VPB VPWR Y
.ends

* Black-box entry subcircuit for sky130_fd_sc_hd__xnor2_2 abstract view
.subckt sky130_fd_sc_hd__xnor2_2 A B VGND VNB VPB VPWR Y
.ends

* Black-box entry subcircuit for sky130_fd_sc_hd__clkbuf_2 abstract view
.subckt sky130_fd_sc_hd__clkbuf_2 A VGND VNB VPB VPWR X
.ends

* Black-box entry subcircuit for sky130_fd_sc_hd__buf_4 abstract view
.subckt sky130_fd_sc_hd__buf_4 A VGND VNB VPB VPWR X
.ends

* Black-box entry subcircuit for sky130_fd_sc_hd__o211ai_4 abstract view
.subckt sky130_fd_sc_hd__o211ai_4 A1 A2 B1 C1 VGND VNB VPB VPWR Y
.ends

* Black-box entry subcircuit for sky130_fd_sc_hd__and2b_2 abstract view
.subckt sky130_fd_sc_hd__and2b_2 A_N B VGND VNB VPB VPWR X
.ends

* Black-box entry subcircuit for sky130_fd_sc_hd__a31oi_2 abstract view
.subckt sky130_fd_sc_hd__a31oi_2 A1 A2 A3 B1 VGND VNB VPB VPWR Y
.ends

* Black-box entry subcircuit for sky130_fd_sc_hd__a31o_4 abstract view
.subckt sky130_fd_sc_hd__a31o_4 A1 A2 A3 B1 VGND VNB VPB VPWR X
.ends

* Black-box entry subcircuit for sky130_fd_sc_hd__inv_4 abstract view
.subckt sky130_fd_sc_hd__inv_4 A VGND VNB VPB VPWR Y
.ends

* Black-box entry subcircuit for sky130_fd_sc_hd__a221o_2 abstract view
.subckt sky130_fd_sc_hd__a221o_2 A1 A2 B1 B2 C1 VGND VNB VPB VPWR X
.ends

* Black-box entry subcircuit for sky130_fd_sc_hd__and4bb_2 abstract view
.subckt sky130_fd_sc_hd__and4bb_2 A_N B_N C D VGND VNB VPB VPWR X
.ends

* Black-box entry subcircuit for sky130_fd_sc_hd__a31oi_4 abstract view
.subckt sky130_fd_sc_hd__a31oi_4 A1 A2 A3 B1 VGND VNB VPB VPWR Y
.ends

* Black-box entry subcircuit for sky130_fd_sc_hd__o22ai_4 abstract view
.subckt sky130_fd_sc_hd__o22ai_4 A1 A2 B1 B2 VGND VNB VPB VPWR Y
.ends

* Black-box entry subcircuit for sky130_fd_sc_hd__or2_2 abstract view
.subckt sky130_fd_sc_hd__or2_2 A B VGND VNB VPB VPWR X
.ends

* Black-box entry subcircuit for sky130_fd_sc_hd__o2bb2ai_4 abstract view
.subckt sky130_fd_sc_hd__o2bb2ai_4 A1_N A2_N B1 B2 VGND VNB VPB VPWR Y
.ends

* Black-box entry subcircuit for sky130_fd_sc_hd__a2bb2oi_4 abstract view
.subckt sky130_fd_sc_hd__a2bb2oi_4 A1_N A2_N B1 B2 VGND VNB VPB VPWR Y
.ends

* Black-box entry subcircuit for sky130_fd_sc_hd__a21bo_2 abstract view
.subckt sky130_fd_sc_hd__a21bo_2 A1 A2 B1_N VGND VNB VPB VPWR X
.ends

* Black-box entry subcircuit for sky130_fd_sc_hd__a311oi_2 abstract view
.subckt sky130_fd_sc_hd__a311oi_2 A1 A2 A3 B1 C1 VGND VNB VPB VPWR Y
.ends

* Black-box entry subcircuit for sky130_fd_sc_hd__o221a_2 abstract view
.subckt sky130_fd_sc_hd__o221a_2 A1 A2 B1 B2 C1 VGND VNB VPB VPWR X
.ends

* Black-box entry subcircuit for sky130_fd_sc_hd__nand2_8 abstract view
.subckt sky130_fd_sc_hd__nand2_8 A B VGND VNB VPB VPWR Y
.ends

* Black-box entry subcircuit for sky130_fd_sc_hd__o2bb2a_2 abstract view
.subckt sky130_fd_sc_hd__o2bb2a_2 A1_N A2_N B1 B2 VGND VNB VPB VPWR X
.ends

* Black-box entry subcircuit for sky130_fd_sc_hd__o21ba_4 abstract view
.subckt sky130_fd_sc_hd__o21ba_4 A1 A2 B1_N VGND VNB VPB VPWR X
.ends

* Black-box entry subcircuit for sky130_fd_sc_hd__o2bb2a_4 abstract view
.subckt sky130_fd_sc_hd__o2bb2a_4 A1_N A2_N B1 B2 VGND VNB VPB VPWR X
.ends

* Black-box entry subcircuit for sky130_fd_sc_hd__o31ai_2 abstract view
.subckt sky130_fd_sc_hd__o31ai_2 A1 A2 A3 B1 VGND VNB VPB VPWR Y
.ends

* Black-box entry subcircuit for sky130_fd_sc_hd__or4b_2 abstract view
.subckt sky130_fd_sc_hd__or4b_2 A B C D_N VGND VNB VPB VPWR X
.ends

* Black-box entry subcircuit for sky130_fd_sc_hd__a21bo_4 abstract view
.subckt sky130_fd_sc_hd__a21bo_4 A1 A2 B1_N VGND VNB VPB VPWR X
.ends

* Black-box entry subcircuit for sky130_fd_sc_hd__a41oi_4 abstract view
.subckt sky130_fd_sc_hd__a41oi_4 A1 A2 A3 A4 B1 VGND VNB VPB VPWR Y
.ends

* Black-box entry subcircuit for sky130_fd_sc_hd__buf_1 abstract view
.subckt sky130_fd_sc_hd__buf_1 A VGND VNB VPB VPWR X
.ends

* Black-box entry subcircuit for sky130_fd_sc_hd__o21ba_2 abstract view
.subckt sky130_fd_sc_hd__o21ba_2 A1 A2 B1_N VGND VNB VPB VPWR X
.ends

* Black-box entry subcircuit for sky130_fd_sc_hd__a311o_2 abstract view
.subckt sky130_fd_sc_hd__a311o_2 A1 A2 A3 B1 C1 VGND VNB VPB VPWR X
.ends

* Black-box entry subcircuit for sky130_fd_sc_hd__nand3b_4 abstract view
.subckt sky130_fd_sc_hd__nand3b_4 A_N B C VGND VNB VPB VPWR Y
.ends

* Black-box entry subcircuit for sky130_fd_sc_hd__o22a_2 abstract view
.subckt sky130_fd_sc_hd__o22a_2 A1 A2 B1 B2 VGND VNB VPB VPWR X
.ends

* Black-box entry subcircuit for sky130_fd_sc_hd__o221ai_4 abstract view
.subckt sky130_fd_sc_hd__o221ai_4 A1 A2 B1 B2 C1 VGND VNB VPB VPWR Y
.ends

* Black-box entry subcircuit for sky130_fd_sc_hd__nor2_4 abstract view
.subckt sky130_fd_sc_hd__nor2_4 A B VGND VNB VPB VPWR Y
.ends

* Black-box entry subcircuit for sky130_fd_sc_hd__a211oi_2 abstract view
.subckt sky130_fd_sc_hd__a211oi_2 A1 A2 B1 C1 VGND VNB VPB VPWR Y
.ends

* Black-box entry subcircuit for sky130_fd_sc_hd__a2bb2o_4 abstract view
.subckt sky130_fd_sc_hd__a2bb2o_4 A1_N A2_N B1 B2 VGND VNB VPB VPWR X
.ends

* Black-box entry subcircuit for sky130_fd_sc_hd__nor3b_2 abstract view
.subckt sky130_fd_sc_hd__nor3b_2 A B C_N VGND VNB VPB VPWR Y
.ends

* Black-box entry subcircuit for sky130_fd_sc_hd__or4bb_4 abstract view
.subckt sky130_fd_sc_hd__or4bb_4 A B C_N D_N VGND VNB VPB VPWR X
.ends

* Black-box entry subcircuit for sky130_fd_sc_hd__o41a_2 abstract view
.subckt sky130_fd_sc_hd__o41a_2 A1 A2 A3 A4 B1 VGND VNB VPB VPWR X
.ends

* Black-box entry subcircuit for sky130_fd_sc_hd__o31a_4 abstract view
.subckt sky130_fd_sc_hd__o31a_4 A1 A2 A3 B1 VGND VNB VPB VPWR X
.ends

* Black-box entry subcircuit for sky130_fd_sc_hd__a41oi_2 abstract view
.subckt sky130_fd_sc_hd__a41oi_2 A1 A2 A3 A4 B1 VGND VNB VPB VPWR Y
.ends

.subckt mac_pe VGND VPWR a_in[0] a_in[1] a_in[2] a_in[3] a_in[4] a_in[5] a_in[6] a_in[7]
+ a_out[0] a_out[1] a_out[2] a_out[3] a_out[4] a_out[5] a_out[6] a_out[7] acc_en b_in[0]
+ b_in[1] b_in[2] b_in[3] b_in[4] b_in[5] b_in[6] b_in[7] b_out[0] b_out[1] b_out[2]
+ b_out[3] b_out[4] b_out[5] b_out[6] b_out[7] clear clk psum_out[0] psum_out[10]
+ psum_out[11] psum_out[12] psum_out[13] psum_out[14] psum_out[15] psum_out[16] psum_out[17]
+ psum_out[1] psum_out[2] psum_out[3] psum_out[4] psum_out[5] psum_out[6] psum_out[7]
+ psum_out[8] psum_out[9] rst_n
XFILLER_39_222 VGND VGND VPWR VPWR sky130_fd_sc_hd__fill_2
XFILLER_39_266 VGND VGND VPWR VPWR sky130_fd_sc_hd__decap_3
XFILLER_22_100 VGND VGND VPWR VPWR sky130_fd_sc_hd__decap_3
XFILLER_22_111 VGND VGND VPWR VPWR sky130_fd_sc_hd__decap_3
XFILLER_22_133 VGND VGND VPWR VPWR sky130_fd_sc_hd__fill_1
XFILLER_22_188 VGND VGND VPWR VPWR sky130_fd_sc_hd__decap_3
XTAP_TAPCELL_ROW_17_191 VGND VPWR sky130_fd_sc_hd__tapvpwrvgnd_1
XTAP_TAPCELL_ROW_9_148 VGND VPWR sky130_fd_sc_hd__tapvpwrvgnd_1
XFILLER_13_122 VGND VGND VPWR VPWR sky130_fd_sc_hd__decap_3
XFILLER_26_85 VGND VGND VPWR VPWR sky130_fd_sc_hd__decap_3
XFILLER_45_225 VGND VGND VPWR VPWR sky130_fd_sc_hd__decap_3
XFILLER_45_258 VGND VGND VPWR VPWR sky130_fd_sc_hd__decap_3
XPHY_EDGE_ROW_37_Left_86 VGND VGND VPWR VPWR sky130_fd_sc_hd__decap_3
XFILLER_13_155 VGND VGND VPWR VPWR sky130_fd_sc_hd__decap_3
XFILLER_13_177 VGND VGND VPWR VPWR sky130_fd_sc_hd__decap_3
XFILLER_42_40 VGND VGND VPWR VPWR sky130_fd_sc_hd__decap_3
XFILLER_3_12 VGND VGND VPWR VPWR sky130_fd_sc_hd__decap_3
X_1270_ clkload5/A _1270_/D wire65/A VGND VGND VPWR VPWR _1270_/Q sky130_fd_sc_hd__dfrtp_2
XFILLER_44_280 VGND VGND VPWR VPWR sky130_fd_sc_hd__decap_3
X_0985_ _0985_/A _1081_/C _0985_/C _0985_/D VGND VGND VPWR VPWR _0991_/C sky130_fd_sc_hd__nand4_2
XFILLER_42_217 VGND VGND VPWR VPWR sky130_fd_sc_hd__decap_3
XFILLER_10_103 VGND VGND VPWR VPWR sky130_fd_sc_hd__decap_3
XFILLER_12_21 VGND VGND VPWR VPWR sky130_fd_sc_hd__fill_1
XFILLER_6_107 VGND VGND VPWR VPWR sky130_fd_sc_hd__fill_2
XFILLER_12_76 VGND VGND VPWR VPWR sky130_fd_sc_hd__fill_2
XFILLER_18_236 VGND VGND VPWR VPWR sky130_fd_sc_hd__decap_3
XFILLER_41_261 VGND VGND VPWR VPWR sky130_fd_sc_hd__decap_3
X_0770_ _1002_/A _1067_/A VGND VGND VPWR VPWR _0774_/A sky130_fd_sc_hd__nand2_2
XFILLER_5_162 VGND VGND VPWR VPWR sky130_fd_sc_hd__decap_3
X_1253_ _1171_/C _1254_/C1 _1150_/X _1252_/Y VGND VGND VPWR VPWR _1253_/X sky130_fd_sc_hd__a211o_2
XFILLER_24_206 VGND VGND VPWR VPWR sky130_fd_sc_hd__decap_3
X_1184_ _1180_/Y _1181_/X _1257_/Q wire55/X VGND VGND VPWR VPWR _1257_/D sky130_fd_sc_hd__a2bb2o_2
XFILLER_32_283 VGND VGND VPWR VPWR sky130_fd_sc_hd__decap_3
X_0968_ _1024_/A _1098_/A _0960_/Y _0961_/Y _0967_/X VGND VGND VPWR VPWR _0970_/A
+ sky130_fd_sc_hd__o2111ai_2
X_0899_ split/A _0899_/B VGND VGND VPWR VPWR _0900_/A sky130_fd_sc_hd__and2_4
XFILLER_15_228 VGND VGND VPWR VPWR sky130_fd_sc_hd__decap_3
XFILLER_23_86 VGND VGND VPWR VPWR sky130_fd_sc_hd__decap_3
XFILLER_2_154 VGND VGND VPWR VPWR sky130_fd_sc_hd__fill_1
XFILLER_2_176 VGND VGND VPWR VPWR sky130_fd_sc_hd__decap_3
XFILLER_17_9 VGND VGND VPWR VPWR sky130_fd_sc_hd__decap_3
XTAP_TAPCELL_ROW_48_348 VGND VPWR sky130_fd_sc_hd__tapvpwrvgnd_1
XFILLER_48_94 VGND VGND VPWR VPWR sky130_fd_sc_hd__fill_2
X_0822_ _0894_/B VGND VGND VPWR VPWR _0822_/Y sky130_fd_sc_hd__inv_2
XTAP_TAPCELL_ROW_31_259 VGND VPWR sky130_fd_sc_hd__tapvpwrvgnd_1
X_0753_ _0711_/B _0810_/B _0745_/Y _0820_/A _1098_/A VGND VGND VPWR VPWR _0757_/C
+ sky130_fd_sc_hd__o2111ai_4
X_0684_ _0683_/C _0684_/A2 _0683_/A VGND VGND VPWR VPWR _0684_/Y sky130_fd_sc_hd__a21oi_2
XPHY_EDGE_ROW_24_Left_73 VGND VGND VPWR VPWR sky130_fd_sc_hd__decap_3
X_1236_ _1236_/A _1236_/B _1236_/C VGND VGND VPWR VPWR _1236_/X sky130_fd_sc_hd__or3_2
X_1305_ _1305_/CLK _1305_/D wire68/X VGND VGND VPWR VPWR _1305_/Q sky130_fd_sc_hd__dfrtp_2
X_1098_ _1098_/A _1120_/B VGND VGND VPWR VPWR _1098_/X sky130_fd_sc_hd__and2_2
X_1167_ _1250_/B _1167_/B VGND VGND VPWR VPWR _1247_/A sky130_fd_sc_hd__or2_4
XTAP_TAPCELL_ROW_22_215 VGND VPWR sky130_fd_sc_hd__tapvpwrvgnd_1
XFILLER_18_53 VGND VGND VPWR VPWR sky130_fd_sc_hd__decap_3
XFILLER_18_97 VGND VGND VPWR VPWR sky130_fd_sc_hd__decap_3
XTAP_TAPCELL_ROW_45_329 VGND VPWR sky130_fd_sc_hd__tapvpwrvgnd_1
XFILLER_11_231 VGND VGND VPWR VPWR sky130_fd_sc_hd__decap_3
XFILLER_34_85 VGND VGND VPWR VPWR sky130_fd_sc_hd__decap_3
XFILLER_7_202 VGND VGND VPWR VPWR sky130_fd_sc_hd__decap_3
XFILLER_7_279 VGND VGND VPWR VPWR sky130_fd_sc_hd__fill_1
XFILLER_7_246 VGND VGND VPWR VPWR sky130_fd_sc_hd__decap_3
XFILLER_38_139 VGND VGND VPWR VPWR sky130_fd_sc_hd__fill_1
X_1021_ _1027_/A _1070_/A _1119_/D _0814_/A VGND VGND VPWR VPWR _1021_/Y sky130_fd_sc_hd__a22oi_2
X_0805_ _0958_/A VGND VGND VPWR VPWR _0805_/Y sky130_fd_sc_hd__inv_2
X_0736_ _0699_/A _0703_/X _0801_/A _0735_/Y VGND VGND VPWR VPWR _0738_/B sky130_fd_sc_hd__o211ai_2
X_0667_ _1282_/Q _0814_/A _0666_/A _0666_/B VGND VGND VPWR VPWR _0668_/B sky130_fd_sc_hd__a22oi_2
XFILLER_29_128 VGND VGND VPWR VPWR sky130_fd_sc_hd__decap_3
XFILLER_37_172 VGND VGND VPWR VPWR sky130_fd_sc_hd__decap_3
X_1219_ _1218_/B _1221_/A _1221_/B VGND VGND VPWR VPWR _1219_/Y sky130_fd_sc_hd__o21ai_2
XFILLER_4_205 VGND VGND VPWR VPWR sky130_fd_sc_hd__decap_3
XFILLER_29_52 VGND VGND VPWR VPWR sky130_fd_sc_hd__decap_3
XFILLER_28_150 VGND VGND VPWR VPWR sky130_fd_sc_hd__fill_1
XFILLER_28_194 VGND VGND VPWR VPWR sky130_fd_sc_hd__fill_2
XFILLER_43_142 VGND VGND VPWR VPWR sky130_fd_sc_hd__fill_2
XTAP_TAPCELL_ROW_41_310 VGND VPWR sky130_fd_sc_hd__tapvpwrvgnd_1
XFILLER_6_12 VGND VGND VPWR VPWR sky130_fd_sc_hd__decap_3
XFILLER_3_260 VGND VGND VPWR VPWR sky130_fd_sc_hd__decap_3
XFILLER_6_89 VGND VGND VPWR VPWR sky130_fd_sc_hd__decap_3
XFILLER_6_67 VGND VGND VPWR VPWR sky130_fd_sc_hd__decap_3
XFILLER_13_3 VGND VGND VPWR VPWR sky130_fd_sc_hd__decap_3
XFILLER_19_161 VGND VGND VPWR VPWR sky130_fd_sc_hd__decap_3
XFILLER_34_197 VGND VGND VPWR VPWR sky130_fd_sc_hd__decap_3
X_1004_ _1004_/A _1047_/A _1049_/A _1004_/D VGND VGND VPWR VPWR _1005_/B sky130_fd_sc_hd__nand4_2
Xrebuffer118 _0747_/Y VGND VGND VPWR VPWR _0756_/A2 sky130_fd_sc_hd__buf_2
Xrebuffer107 _0848_/Y VGND VGND VPWR VPWR _0850_/B1 sky130_fd_sc_hd__buf_2
X_0719_ _1002_/A VGND VGND VPWR VPWR _0846_/A sky130_fd_sc_hd__inv_2
XFILLER_25_164 VGND VGND VPWR VPWR sky130_fd_sc_hd__decap_3
XPHY_EDGE_ROW_11_Left_60 VGND VGND VPWR VPWR sky130_fd_sc_hd__decap_3
XFILLER_31_20 VGND VGND VPWR VPWR sky130_fd_sc_hd__decap_3
XFILLER_31_42 VGND VGND VPWR VPWR sky130_fd_sc_hd__decap_3
Xoutput20 _1284_/Q VGND VGND VPWR VPWR a_out[2] sky130_fd_sc_hd__clkdlybuf4s25_1
Xoutput42 _1265_/Q VGND VGND VPWR VPWR psum_out[17] sky130_fd_sc_hd__clkdlybuf4s25_1
Xoutput31 _1295_/Q VGND VGND VPWR VPWR b_out[5] sky130_fd_sc_hd__clkdlybuf4s25_1
XFILLER_48_256 VGND VGND VPWR VPWR sky130_fd_sc_hd__decap_3
XFILLER_48_234 VGND VGND VPWR VPWR sky130_fd_sc_hd__fill_2
XFILLER_48_212 VGND VGND VPWR VPWR sky130_fd_sc_hd__decap_3
XFILLER_16_120 VGND VGND VPWR VPWR sky130_fd_sc_hd__decap_3
XFILLER_16_164 VGND VGND VPWR VPWR sky130_fd_sc_hd__decap_3
XFILLER_31_167 VGND VGND VPWR VPWR sky130_fd_sc_hd__fill_1
XFILLER_31_189 VGND VGND VPWR VPWR sky130_fd_sc_hd__fill_1
XFILLER_39_245 VGND VGND VPWR VPWR sky130_fd_sc_hd__decap_3
XFILLER_39_278 VGND VGND VPWR VPWR sky130_fd_sc_hd__fill_2
XFILLER_22_167 VGND VGND VPWR VPWR sky130_fd_sc_hd__decap_3
XTAP_TAPCELL_ROW_17_192 VGND VPWR sky130_fd_sc_hd__tapvpwrvgnd_1
XTAP_TAPCELL_ROW_9_149 VGND VPWR sky130_fd_sc_hd__tapvpwrvgnd_1
XFILLER_13_134 VGND VGND VPWR VPWR sky130_fd_sc_hd__decap_3
XFILLER_13_167 VGND VGND VPWR VPWR sky130_fd_sc_hd__fill_1
XFILLER_26_75 VGND VGND VPWR VPWR sky130_fd_sc_hd__decap_3
XFILLER_45_237 VGND VGND VPWR VPWR sky130_fd_sc_hd__decap_3
Xclkbuf_3_6__f_clk clkbuf_0_clk/X VGND VGND VPWR VPWR clkload4/A sky130_fd_sc_hd__clkbuf_16
XFILLER_13_189 VGND VGND VPWR VPWR sky130_fd_sc_hd__decap_3
XFILLER_3_57 VGND VGND VPWR VPWR sky130_fd_sc_hd__fill_2
XFILLER_36_259 VGND VGND VPWR VPWR sky130_fd_sc_hd__decap_3
X_0984_ _0984_/A1 _0897_/X _0971_/Y _0978_/A VGND VGND VPWR VPWR _0985_/C sky130_fd_sc_hd__o211ai_2
XTAP_TAPCELL_ROW_14_173 VGND VPWR sky130_fd_sc_hd__tapvpwrvgnd_1
XFILLER_8_171 VGND VGND VPWR VPWR sky130_fd_sc_hd__decap_3
XFILLER_27_204 VGND VGND VPWR VPWR sky130_fd_sc_hd__decap_3
XFILLER_27_237 VGND VGND VPWR VPWR sky130_fd_sc_hd__decap_3
XFILLER_35_281 VGND VGND VPWR VPWR sky130_fd_sc_hd__decap_3
XFILLER_42_229 VGND VGND VPWR VPWR sky130_fd_sc_hd__decap_3
XFILLER_12_55 VGND VGND VPWR VPWR sky130_fd_sc_hd__decap_3
XTAP_TAPCELL_ROW_5_130 VGND VPWR sky130_fd_sc_hd__tapvpwrvgnd_1
XFILLER_18_248 VGND VGND VPWR VPWR sky130_fd_sc_hd__decap_3
XFILLER_37_52 VGND VGND VPWR VPWR sky130_fd_sc_hd__decap_3
XTAP_TAPCELL_ROW_28_243 VGND VPWR sky130_fd_sc_hd__tapvpwrvgnd_1
XFILLER_26_281 VGND VGND VPWR VPWR sky130_fd_sc_hd__decap_3
XFILLER_41_240 VGND VGND VPWR VPWR sky130_fd_sc_hd__decap_3
XFILLER_41_273 VGND VGND VPWR VPWR sky130_fd_sc_hd__decap_3
XFILLER_41_284 VGND VGND VPWR VPWR sky130_fd_sc_hd__fill_2
XFILLER_45_6 VGND VGND VPWR VPWR sky130_fd_sc_hd__decap_3
XFILLER_5_196 VGND VGND VPWR VPWR sky130_fd_sc_hd__decap_3
XFILLER_5_185 VGND VGND VPWR VPWR sky130_fd_sc_hd__decap_3
X_1252_ _1305_/Q _1273_/Q VGND VGND VPWR VPWR _1252_/Y sky130_fd_sc_hd__nor2_2
XFILLER_17_281 VGND VGND VPWR VPWR sky130_fd_sc_hd__decap_3
XFILLER_24_218 VGND VGND VPWR VPWR sky130_fd_sc_hd__decap_3
XFILLER_32_240 VGND VGND VPWR VPWR sky130_fd_sc_hd__decap_3
X_1183_ _1183_/A VGND VGND VPWR VPWR wire55/A sky130_fd_sc_hd__clkbuf_1
XFILLER_32_251 VGND VGND VPWR VPWR sky130_fd_sc_hd__fill_1
X_0967_ split/X _1070_/A _0967_/C VGND VGND VPWR VPWR _0967_/X sky130_fd_sc_hd__and3_2
X_0898_ _0961_/C VGND VGND VPWR VPWR _1070_/A sky130_fd_sc_hd__buf_8
XPHY_EDGE_ROW_12_Right_12 VGND VGND VPWR VPWR sky130_fd_sc_hd__decap_3
XPHY_EDGE_ROW_21_Right_21 VGND VGND VPWR VPWR sky130_fd_sc_hd__decap_3
XFILLER_15_218 VGND VGND VPWR VPWR sky130_fd_sc_hd__decap_3
XFILLER_23_21 VGND VGND VPWR VPWR sky130_fd_sc_hd__fill_2
XFILLER_23_251 VGND VGND VPWR VPWR sky130_fd_sc_hd__decap_3
XFILLER_23_284 VGND VGND VPWR VPWR sky130_fd_sc_hd__fill_2
XFILLER_23_43 VGND VGND VPWR VPWR sky130_fd_sc_hd__decap_3
XFILLER_23_98 VGND VGND VPWR VPWR sky130_fd_sc_hd__decap_3
XPHY_EDGE_ROW_30_Right_30 VGND VGND VPWR VPWR sky130_fd_sc_hd__decap_3
XFILLER_48_40 VGND VGND VPWR VPWR sky130_fd_sc_hd__decap_3
XTAP_TAPCELL_ROW_48_349 VGND VPWR sky130_fd_sc_hd__tapvpwrvgnd_1
XFILLER_9_12 VGND VGND VPWR VPWR sky130_fd_sc_hd__decap_3
XFILLER_14_262 VGND VGND VPWR VPWR sky130_fd_sc_hd__fill_2
X_0821_ _0890_/A _0888_/A _1023_/B _0894_/B _0810_/Y VGND VGND VPWR VPWR _0821_/Y
+ sky130_fd_sc_hd__o2111ai_4
X_0752_ _0745_/Y _0746_/Y _0749_/X VGND VGND VPWR VPWR _0757_/B sky130_fd_sc_hd__a21o_2
XFILLER_9_67 VGND VGND VPWR VPWR sky130_fd_sc_hd__decap_3
XFILLER_43_3 VGND VGND VPWR VPWR sky130_fd_sc_hd__decap_3
X_0683_ _0683_/A _0683_/B _0683_/C VGND VGND VPWR VPWR _0683_/X sky130_fd_sc_hd__and3_4
X_1166_ _1303_/Q _1271_/Q VGND VGND VPWR VPWR _1167_/B sky130_fd_sc_hd__nor2_2
X_1235_ _1191_/B _1236_/A _1234_/X _1140_/A VGND VGND VPWR VPWR _1298_/D sky130_fd_sc_hd__o211a_2
X_1304_ _1305_/CLK _1304_/D wire68/X VGND VGND VPWR VPWR _1304_/Q sky130_fd_sc_hd__dfrtp_2
X_1097_ _1120_/A _1120_/B _1120_/C VGND VGND VPWR VPWR _1103_/A sky130_fd_sc_hd__nand3_2
XTAP_TAPCELL_ROW_22_216 VGND VPWR sky130_fd_sc_hd__tapvpwrvgnd_1
XFILLER_18_21 VGND VGND VPWR VPWR sky130_fd_sc_hd__decap_3
XFILLER_18_32 VGND VGND VPWR VPWR sky130_fd_sc_hd__decap_3
XFILLER_11_276 VGND VGND VPWR VPWR sky130_fd_sc_hd__decap_3
XPHY_EDGE_ROW_41_Left_90 VGND VGND VPWR VPWR sky130_fd_sc_hd__decap_3
XFILLER_7_258 VGND VGND VPWR VPWR sky130_fd_sc_hd__decap_3
X_1020_ _1020_/A VGND VGND VPWR VPWR _1119_/D sky130_fd_sc_hd__buf_6
XFILLER_46_184 VGND VGND VPWR VPWR sky130_fd_sc_hd__decap_3
X_0804_ _1289_/Q VGND VGND VPWR VPWR _0899_/B sky130_fd_sc_hd__buf_8
X_0735_ _0735_/A _0735_/B _0735_/C VGND VGND VPWR VPWR _0735_/Y sky130_fd_sc_hd__nand3_2
X_0666_ _0666_/A _0666_/B _1282_/Q _0814_/A VGND VGND VPWR VPWR _0668_/A sky130_fd_sc_hd__and4_2
X_1149_ _1256_/Q _1274_/Q VGND VGND VPWR VPWR _1174_/B sky130_fd_sc_hd__xor2_2
X_1218_ _1221_/B _1218_/B _1221_/A VGND VGND VPWR VPWR _1218_/X sky130_fd_sc_hd__or3_2
XFILLER_20_11 VGND VGND VPWR VPWR sky130_fd_sc_hd__decap_3
XFILLER_20_55 VGND VGND VPWR VPWR sky130_fd_sc_hd__decap_3
XFILLER_20_88 VGND VGND VPWR VPWR sky130_fd_sc_hd__decap_3
XFILLER_45_63 VGND VGND VPWR VPWR sky130_fd_sc_hd__decap_3
XTAP_TAPCELL_ROW_41_311 VGND VPWR sky130_fd_sc_hd__tapvpwrvgnd_1
XFILLER_6_24 VGND VGND VPWR VPWR sky130_fd_sc_hd__decap_3
XFILLER_6_79 VGND VGND VPWR VPWR sky130_fd_sc_hd__decap_3
XFILLER_19_184 VGND VGND VPWR VPWR sky130_fd_sc_hd__fill_1
XFILLER_34_110 VGND VGND VPWR VPWR sky130_fd_sc_hd__decap_3
X_1003_ _1003_/A _1003_/B VGND VGND VPWR VPWR _1005_/C sky130_fd_sc_hd__nand2_2
XFILLER_34_187 VGND VGND VPWR VPWR sky130_fd_sc_hd__decap_3
Xrebuffer119 _0716_/Y VGND VGND VPWR VPWR _0773_/A1 sky130_fd_sc_hd__buf_2
Xrebuffer108 _0816_/A VGND VGND VPWR VPWR _0713_/B sky130_fd_sc_hd__buf_2
X_0718_ _0718_/A _0814_/A _1002_/A _0718_/D VGND VGND VPWR VPWR _0768_/A sky130_fd_sc_hd__nand4_4
XPHY_EDGE_ROW_6_Right_6 VGND VGND VPWR VPWR sky130_fd_sc_hd__decap_3
X_0649_ _1023_/B VGND VGND VPWR VPWR _1098_/A sky130_fd_sc_hd__buf_6
XFILLER_15_88 VGND VGND VPWR VPWR sky130_fd_sc_hd__decap_3
XFILLER_0_253 VGND VGND VPWR VPWR sky130_fd_sc_hd__decap_3
XFILLER_31_87 VGND VGND VPWR VPWR sky130_fd_sc_hd__decap_3
Xoutput21 _1285_/Q VGND VGND VPWR VPWR a_out[3] sky130_fd_sc_hd__clkdlybuf4s25_1
Xoutput43 _1238_/B1 VGND VGND VPWR VPWR psum_out[1] sky130_fd_sc_hd__clkdlybuf4s25_1
Xoutput32 _1296_/Q VGND VGND VPWR VPWR b_out[6] sky130_fd_sc_hd__clkdlybuf4s25_1
XFILLER_48_268 VGND VGND VPWR VPWR sky130_fd_sc_hd__decap_3
XFILLER_31_102 VGND VGND VPWR VPWR sky130_fd_sc_hd__decap_3
XFILLER_31_113 VGND VGND VPWR VPWR sky130_fd_sc_hd__decap_3
XFILLER_39_257 VGND VGND VPWR VPWR sky130_fd_sc_hd__decap_3
XFILLER_22_124 VGND VGND VPWR VPWR sky130_fd_sc_hd__decap_3
XFILLER_22_179 VGND VGND VPWR VPWR sky130_fd_sc_hd__decap_3
XFILLER_45_249 VGND VGND VPWR VPWR sky130_fd_sc_hd__decap_3
XFILLER_13_113 VGND VGND VPWR VPWR sky130_fd_sc_hd__decap_3
XFILLER_13_146 VGND VGND VPWR VPWR sky130_fd_sc_hd__decap_3
XFILLER_9_128 VGND VGND VPWR VPWR sky130_fd_sc_hd__decap_3
XFILLER_42_75 VGND VGND VPWR VPWR sky130_fd_sc_hd__decap_3
XFILLER_36_227 VGND VGND VPWR VPWR sky130_fd_sc_hd__decap_3
XFILLER_36_249 VGND VGND VPWR VPWR sky130_fd_sc_hd__decap_3
XFILLER_44_271 VGND VGND VPWR VPWR sky130_fd_sc_hd__decap_3
X_0983_ _0978_/A _0978_/C _0971_/Y VGND VGND VPWR VPWR _0985_/A sky130_fd_sc_hd__a21o_2
XTAP_TAPCELL_ROW_14_174 VGND VPWR sky130_fd_sc_hd__tapvpwrvgnd_1
XFILLER_8_150 VGND VGND VPWR VPWR sky130_fd_sc_hd__decap_3
XFILLER_27_249 VGND VGND VPWR VPWR sky130_fd_sc_hd__decap_3
XFILLER_35_271 VGND VGND VPWR VPWR sky130_fd_sc_hd__decap_3
XTAP_TAPCELL_ROW_37_288 VGND VPWR sky130_fd_sc_hd__tapvpwrvgnd_1
XFILLER_10_138 VGND VGND VPWR VPWR sky130_fd_sc_hd__fill_2
XFILLER_12_12 VGND VGND VPWR VPWR sky130_fd_sc_hd__decap_3
XTAP_TAPCELL_ROW_5_131 VGND VPWR sky130_fd_sc_hd__tapvpwrvgnd_1
XFILLER_5_6 VGND VGND VPWR VPWR sky130_fd_sc_hd__decap_3
XFILLER_18_216 VGND VGND VPWR VPWR sky130_fd_sc_hd__decap_3
XFILLER_37_31 VGND VGND VPWR VPWR sky130_fd_sc_hd__decap_3
XFILLER_37_86 VGND VGND VPWR VPWR sky130_fd_sc_hd__fill_1
XTAP_TAPCELL_ROW_28_244 VGND VPWR sky130_fd_sc_hd__tapvpwrvgnd_1
XFILLER_41_252 VGND VGND VPWR VPWR sky130_fd_sc_hd__decap_3
XFILLER_38_6 VGND VGND VPWR VPWR sky130_fd_sc_hd__decap_3
X_1182_ _1182_/A _1191_/A VGND VGND VPWR VPWR _1183_/A sky130_fd_sc_hd__nor2_2
X_1251_ _1254_/C1 _1250_/X _1255_/A2 _1304_/Q wire55/X VGND VGND VPWR VPWR _1304_/D
+ sky130_fd_sc_hd__a32o_2
XTAP_TAPCELL_ROW_19_200 VGND VPWR sky130_fd_sc_hd__tapvpwrvgnd_1
XFILLER_32_274 VGND VGND VPWR VPWR sky130_fd_sc_hd__decap_3
X_0966_ _0977_/A _0977_/B _0977_/C VGND VGND VPWR VPWR _1035_/A sky130_fd_sc_hd__nand3_2
X_0897_ _0894_/Y _0895_/Y _0896_/Y VGND VGND VPWR VPWR _0897_/X sky130_fd_sc_hd__o21a_4
XFILLER_23_274 VGND VGND VPWR VPWR sky130_fd_sc_hd__decap_3
XFILLER_23_55 VGND VGND VPWR VPWR sky130_fd_sc_hd__fill_1
XFILLER_23_66 VGND VGND VPWR VPWR sky130_fd_sc_hd__decap_3
XFILLER_3_3 VGND VGND VPWR VPWR sky130_fd_sc_hd__decap_3
XFILLER_0_15 VGND VGND VPWR VPWR sky130_fd_sc_hd__decap_3
XFILLER_48_85 VGND VGND VPWR VPWR sky130_fd_sc_hd__decap_3
XFILLER_48_74 VGND VGND VPWR VPWR sky130_fd_sc_hd__fill_2
XFILLER_48_52 VGND VGND VPWR VPWR sky130_fd_sc_hd__decap_3
X_0820_ _0820_/A VGND VGND VPWR VPWR _0903_/B sky130_fd_sc_hd__inv_2
X_0751_ _0750_/X _0751_/A2 _0713_/Y VGND VGND VPWR VPWR _0755_/B sky130_fd_sc_hd__o21bai_4
XFILLER_36_3 VGND VGND VPWR VPWR sky130_fd_sc_hd__decap_3
X_1303_ _1305_/CLK _1303_/D fanout66/X VGND VGND VPWR VPWR _1303_/Q sky130_fd_sc_hd__dfrtp_2
X_0682_ _1098_/A _1284_/Q VGND VGND VPWR VPWR _0683_/A sky130_fd_sc_hd__and2_2
X_1096_ _1063_/Y _1064_/Y _1093_/B _1090_/B VGND VGND VPWR VPWR _1115_/A sky130_fd_sc_hd__o31ai_4
X_1165_ _1165_/A _1165_/B VGND VGND VPWR VPWR _1165_/Y sky130_fd_sc_hd__nand2_4
X_1234_ _1182_/A _1266_/Q _1298_/Q VGND VGND VPWR VPWR _1234_/X sky130_fd_sc_hd__a21o_2
XFILLER_20_211 VGND VGND VPWR VPWR sky130_fd_sc_hd__decap_3
XTAP_TAPCELL_ROW_22_217 VGND VPWR sky130_fd_sc_hd__tapvpwrvgnd_1
X_0949_ _0879_/C _0866_/Y _0872_/Y VGND VGND VPWR VPWR _0949_/Y sky130_fd_sc_hd__a21oi_4
XFILLER_18_44 VGND VGND VPWR VPWR sky130_fd_sc_hd__decap_3
XFILLER_18_88 VGND VGND VPWR VPWR sky130_fd_sc_hd__decap_3
XFILLER_11_222 VGND VGND VPWR VPWR sky130_fd_sc_hd__fill_2
XFILLER_7_237 VGND VGND VPWR VPWR sky130_fd_sc_hd__decap_3
XFILLER_46_141 VGND VGND VPWR VPWR sky130_fd_sc_hd__decap_3
X_0803_ _0803_/A VGND VGND VPWR VPWR _0803_/Y sky130_fd_sc_hd__inv_2
X_0734_ _0735_/B _0735_/C _0735_/A VGND VGND VPWR VPWR _0801_/A sky130_fd_sc_hd__a21o_4
X_0665_ _1029_/C VGND VGND VPWR VPWR _0814_/A sky130_fd_sc_hd__buf_6
XFILLER_37_130 VGND VGND VPWR VPWR sky130_fd_sc_hd__decap_3
XFILLER_37_163 VGND VGND VPWR VPWR sky130_fd_sc_hd__decap_3
XFILLER_37_196 VGND VGND VPWR VPWR sky130_fd_sc_hd__fill_2
X_1079_ _1078_/X _1074_/X _1076_/X VGND VGND VPWR VPWR _1081_/A sky130_fd_sc_hd__a21o_4
X_1148_ _1182_/A VGND VGND VPWR VPWR _1191_/B sky130_fd_sc_hd__inv_2
X_1217_ _1262_/Q _1280_/Q VGND VGND VPWR VPWR _1221_/A sky130_fd_sc_hd__nor2_2
XFILLER_20_45 VGND VGND VPWR VPWR sky130_fd_sc_hd__fill_2
XFILLER_20_78 VGND VGND VPWR VPWR sky130_fd_sc_hd__decap_3
XFILLER_29_76 VGND VGND VPWR VPWR sky130_fd_sc_hd__decap_3
XFILLER_28_185 VGND VGND VPWR VPWR sky130_fd_sc_hd__decap_3
XFILLER_43_155 VGND VGND VPWR VPWR sky130_fd_sc_hd__decap_3
XFILLER_43_177 VGND VGND VPWR VPWR sky130_fd_sc_hd__fill_2
XTAP_TAPCELL_ROW_41_312 VGND VPWR sky130_fd_sc_hd__tapvpwrvgnd_1
XFILLER_3_284 VGND VGND VPWR VPWR sky130_fd_sc_hd__fill_2
X_1002_ _1002_/A _1297_/Q VGND VGND VPWR VPWR _1002_/X sky130_fd_sc_hd__and2_2
Xrebuffer109 _0683_/X VGND VGND VPWR VPWR _0726_/A2 sky130_fd_sc_hd__buf_2
X_0717_ _0717_/A1 _0712_/B _0716_/Y _0683_/B VGND VGND VPWR VPWR _0718_/A sky130_fd_sc_hd__a211o_4
X_0648_ _0958_/A VGND VGND VPWR VPWR _1023_/B sky130_fd_sc_hd__buf_12
XFILLER_15_67 VGND VGND VPWR VPWR sky130_fd_sc_hd__fill_2
XFILLER_25_155 VGND VGND VPWR VPWR sky130_fd_sc_hd__decap_3
XFILLER_25_199 VGND VGND VPWR VPWR sky130_fd_sc_hd__decap_3
XFILLER_40_103 VGND VGND VPWR VPWR sky130_fd_sc_hd__fill_1
XFILLER_40_125 VGND VGND VPWR VPWR sky130_fd_sc_hd__decap_3
XFILLER_40_136 VGND VGND VPWR VPWR sky130_fd_sc_hd__decap_3
XFILLER_40_158 VGND VGND VPWR VPWR sky130_fd_sc_hd__decap_3
XFILLER_31_99 VGND VGND VPWR VPWR sky130_fd_sc_hd__decap_3
XFILLER_0_221 VGND VGND VPWR VPWR sky130_fd_sc_hd__decap_3
XFILLER_0_243 VGND VGND VPWR VPWR sky130_fd_sc_hd__fill_1
Xoutput22 _0713_/C VGND VGND VPWR VPWR a_out[4] sky130_fd_sc_hd__clkdlybuf4s25_1
Xoutput44 _1300_/Q VGND VGND VPWR VPWR psum_out[2] sky130_fd_sc_hd__clkdlybuf4s25_1
Xoutput33 _1297_/Q VGND VGND VPWR VPWR b_out[7] sky130_fd_sc_hd__clkdlybuf4s25_1
XFILLER_48_225 VGND VGND VPWR VPWR sky130_fd_sc_hd__decap_3
XFILLER_48_203 VGND VGND VPWR VPWR sky130_fd_sc_hd__decap_3
XFILLER_48_247 VGND VGND VPWR VPWR sky130_fd_sc_hd__decap_3
XFILLER_16_188 VGND VGND VPWR VPWR sky130_fd_sc_hd__decap_3
XFILLER_31_125 VGND VGND VPWR VPWR sky130_fd_sc_hd__decap_3
XFILLER_31_158 VGND VGND VPWR VPWR sky130_fd_sc_hd__fill_1
XFILLER_31_169 VGND VGND VPWR VPWR sky130_fd_sc_hd__decap_3
XFILLER_39_269 VGND VGND VPWR VPWR sky130_fd_sc_hd__decap_3
XFILLER_22_103 VGND VGND VPWR VPWR sky130_fd_sc_hd__fill_2
XFILLER_22_114 VGND VGND VPWR VPWR sky130_fd_sc_hd__decap_3
XFILLER_30_180 VGND VGND VPWR VPWR sky130_fd_sc_hd__decap_3
XFILLER_38_280 VGND VGND VPWR VPWR sky130_fd_sc_hd__decap_3
XFILLER_45_217 VGND VGND VPWR VPWR sky130_fd_sc_hd__decap_3
XFILLER_45_228 VGND VGND VPWR VPWR sky130_fd_sc_hd__decap_3
XFILLER_13_125 VGND VGND VPWR VPWR sky130_fd_sc_hd__decap_3
XFILLER_13_158 VGND VGND VPWR VPWR sky130_fd_sc_hd__fill_2
XFILLER_13_169 VGND VGND VPWR VPWR sky130_fd_sc_hd__decap_3
XFILLER_26_88 VGND VGND VPWR VPWR sky130_fd_sc_hd__fill_1
XFILLER_42_43 VGND VGND VPWR VPWR sky130_fd_sc_hd__fill_1
XFILLER_3_15 VGND VGND VPWR VPWR sky130_fd_sc_hd__fill_2
XFILLER_44_283 VGND VGND VPWR VPWR sky130_fd_sc_hd__decap_3
X_0982_ _0976_/Y _0979_/X _0981_/Y VGND VGND VPWR VPWR _0988_/B sky130_fd_sc_hd__o21ai_2
XTAP_TAPCELL_ROW_14_175 VGND VPWR sky130_fd_sc_hd__tapvpwrvgnd_1
XFILLER_8_162 VGND VGND VPWR VPWR sky130_fd_sc_hd__decap_3
XFILLER_10_106 VGND VGND VPWR VPWR sky130_fd_sc_hd__decap_3
XTAP_TAPCELL_ROW_37_289 VGND VPWR sky130_fd_sc_hd__tapvpwrvgnd_1
XFILLER_12_46 VGND VGND VPWR VPWR sky130_fd_sc_hd__decap_3
XFILLER_12_68 VGND VGND VPWR VPWR sky130_fd_sc_hd__decap_3
XTAP_TAPCELL_ROW_5_132 VGND VPWR sky130_fd_sc_hd__tapvpwrvgnd_1
XFILLER_18_239 VGND VGND VPWR VPWR sky130_fd_sc_hd__decap_3
XFILLER_41_231 VGND VGND VPWR VPWR sky130_fd_sc_hd__decap_3
XTAP_TAPCELL_ROW_28_245 VGND VPWR sky130_fd_sc_hd__tapvpwrvgnd_1
XFILLER_41_264 VGND VGND VPWR VPWR sky130_fd_sc_hd__decap_3
XFILLER_5_165 VGND VGND VPWR VPWR sky130_fd_sc_hd__decap_3
XFILLER_5_132 VGND VGND VPWR VPWR sky130_fd_sc_hd__decap_3
XFILLER_24_209 VGND VGND VPWR VPWR sky130_fd_sc_hd__decap_3
X_1181_ _1180_/B _1180_/A _0799_/A _1191_/B VGND VGND VPWR VPWR _1181_/X sky130_fd_sc_hd__a211o_2
X_1250_ _1250_/A _1250_/B _1250_/C VGND VGND VPWR VPWR _1250_/X sky130_fd_sc_hd__or3_2
XTAP_TAPCELL_ROW_19_201 VGND VPWR sky130_fd_sc_hd__tapvpwrvgnd_1
XFILLER_32_231 VGND VGND VPWR VPWR sky130_fd_sc_hd__decap_3
XFILLER_32_253 VGND VGND VPWR VPWR sky130_fd_sc_hd__decap_3
X_0965_ _0890_/B _0964_/Y _0890_/A _0889_/Y _0960_/Y VGND VGND VPWR VPWR _0977_/C
+ sky130_fd_sc_hd__o221ai_2
X_0896_ _1023_/B _0810_/A _0894_/B _1024_/A _0807_/X VGND VGND VPWR VPWR _0896_/Y
+ sky130_fd_sc_hd__o2111ai_4
XTAP_TAPCELL_ROW_2_113 VGND VPWR sky130_fd_sc_hd__tapvpwrvgnd_1
XFILLER_15_209 VGND VGND VPWR VPWR sky130_fd_sc_hd__decap_3
XFILLER_23_12 VGND VGND VPWR VPWR sky130_fd_sc_hd__decap_3
XFILLER_23_242 VGND VGND VPWR VPWR sky130_fd_sc_hd__decap_3
XFILLER_23_34 VGND VGND VPWR VPWR sky130_fd_sc_hd__decap_3
XFILLER_23_78 VGND VGND VPWR VPWR sky130_fd_sc_hd__decap_3
XFILLER_23_89 VGND VGND VPWR VPWR sky130_fd_sc_hd__decap_3
XTAP_TAPCELL_ROW_33_270 VGND VPWR sky130_fd_sc_hd__tapvpwrvgnd_1
XFILLER_2_179 VGND VGND VPWR VPWR sky130_fd_sc_hd__decap_3
XFILLER_0_27 VGND VGND VPWR VPWR sky130_fd_sc_hd__fill_1
XFILLER_14_253 VGND VGND VPWR VPWR sky130_fd_sc_hd__decap_3
X_0750_ _0711_/B _0810_/B _0749_/X _0745_/Y VGND VGND VPWR VPWR _0750_/X sky130_fd_sc_hd__o211a_2
X_0681_ _0681_/A _1024_/A _1285_/Q _0820_/A VGND VGND VPWR VPWR _0683_/B sky130_fd_sc_hd__nand4_4
XFILLER_29_3 VGND VGND VPWR VPWR sky130_fd_sc_hd__decap_3
X_1233_ _1265_/Q _1231_/X _1232_/Y VGND VGND VPWR VPWR _1265_/D sky130_fd_sc_hd__o21a_2
X_1302_ clkload5/A _1302_/D fanout66/X VGND VGND VPWR VPWR _1302_/Q sky130_fd_sc_hd__dfrtp_2
X_1095_ _1089_/X _1062_/C _1091_/X _1094_/Y VGND VGND VPWR VPWR _1277_/D sky130_fd_sc_hd__o211a_2
X_1164_ _1302_/Q _1270_/Q VGND VGND VPWR VPWR _1165_/B sky130_fd_sc_hd__xor2_2
XTAP_TAPCELL_ROW_47_340 VGND VPWR sky130_fd_sc_hd__tapvpwrvgnd_1
X_0948_ _0948_/A _0948_/B VGND VGND VPWR VPWR _0950_/A sky130_fd_sc_hd__nand2_2
X_0879_ _0879_/A _0879_/B _0879_/C VGND VGND VPWR VPWR _0880_/B sky130_fd_sc_hd__nand3_2
XFILLER_18_12 VGND VGND VPWR VPWR sky130_fd_sc_hd__decap_3
XFILLER_18_56 VGND VGND VPWR VPWR sky130_fd_sc_hd__decap_3
XFILLER_11_234 VGND VGND VPWR VPWR sky130_fd_sc_hd__decap_3
XFILLER_7_249 VGND VGND VPWR VPWR sky130_fd_sc_hd__decap_3
XFILLER_7_205 VGND VGND VPWR VPWR sky130_fd_sc_hd__decap_3
XFILLER_46_197 VGND VGND VPWR VPWR sky130_fd_sc_hd__decap_3
XPHY_EDGE_ROW_28_Left_77 VGND VGND VPWR VPWR sky130_fd_sc_hd__decap_3
X_0802_ _0796_/X _0801_/Y _0797_/Y VGND VGND VPWR VPWR _1058_/B sky130_fd_sc_hd__o21bai_4
X_0733_ _0870_/A _0985_/D VGND VGND VPWR VPWR _0735_/A sky130_fd_sc_hd__nand2_2
X_0664_ _1293_/Q VGND VGND VPWR VPWR _1029_/C sky130_fd_sc_hd__buf_2
XFILLER_37_142 VGND VGND VPWR VPWR sky130_fd_sc_hd__decap_3
X_1216_ _1262_/Q _1280_/Q VGND VGND VPWR VPWR _1218_/B sky130_fd_sc_hd__and2_2
XFILLER_1_70 VGND VGND VPWR VPWR sky130_fd_sc_hd__decap_3
XFILLER_37_175 VGND VGND VPWR VPWR sky130_fd_sc_hd__decap_3
X_1078_ _1120_/C _1120_/B _1071_/B _1120_/A _1073_/Y VGND VGND VPWR VPWR _1078_/X
+ sky130_fd_sc_hd__a41o_2
X_1147_ acc_en VGND VGND VPWR VPWR _1147_/X sky130_fd_sc_hd__clkbuf_1
XFILLER_4_208 VGND VGND VPWR VPWR sky130_fd_sc_hd__decap_3
XFILLER_28_164 VGND VGND VPWR VPWR sky130_fd_sc_hd__decap_3
XFILLER_28_197 VGND VGND VPWR VPWR sky130_fd_sc_hd__decap_3
XFILLER_29_55 VGND VGND VPWR VPWR sky130_fd_sc_hd__fill_1
XFILLER_3_263 VGND VGND VPWR VPWR sky130_fd_sc_hd__fill_2
XFILLER_6_15 VGND VGND VPWR VPWR sky130_fd_sc_hd__decap_3
XFILLER_13_6 VGND VGND VPWR VPWR sky130_fd_sc_hd__decap_3
XFILLER_19_164 VGND VGND VPWR VPWR sky130_fd_sc_hd__decap_3
XFILLER_34_178 VGND VGND VPWR VPWR sky130_fd_sc_hd__decap_3
X_1001_ _1001_/A _1001_/B _1002_/A _1001_/D VGND VGND VPWR VPWR _1018_/B sky130_fd_sc_hd__nand4_4
X_0716_ _1023_/B _1285_/Q _0713_/Y _0711_/Y VGND VGND VPWR VPWR _0716_/Y sky130_fd_sc_hd__a22oi_4
X_0647_ _1292_/Q VGND VGND VPWR VPWR _0958_/A sky130_fd_sc_hd__buf_6
XFILLER_15_24 VGND VGND VPWR VPWR sky130_fd_sc_hd__decap_3
XFILLER_25_167 VGND VGND VPWR VPWR sky130_fd_sc_hd__fill_1
XFILLER_31_23 VGND VGND VPWR VPWR sky130_fd_sc_hd__fill_2
XFILLER_31_45 VGND VGND VPWR VPWR sky130_fd_sc_hd__decap_3
XFILLER_31_78 VGND VGND VPWR VPWR sky130_fd_sc_hd__decap_3
Xoutput23 output23/A VGND VGND VPWR VPWR a_out[5] sky130_fd_sc_hd__clkdlybuf4s25_1
Xoutput34 _1298_/Q VGND VGND VPWR VPWR psum_out[0] sky130_fd_sc_hd__clkdlybuf4s25_1
XFILLER_0_233 VGND VGND VPWR VPWR sky130_fd_sc_hd__fill_2
Xoutput45 _1301_/Q VGND VGND VPWR VPWR psum_out[3] sky130_fd_sc_hd__clkdlybuf4s25_1
XFILLER_48_259 VGND VGND VPWR VPWR sky130_fd_sc_hd__decap_3
XFILLER_48_215 VGND VGND VPWR VPWR sky130_fd_sc_hd__decap_3
XFILLER_16_123 VGND VGND VPWR VPWR sky130_fd_sc_hd__decap_3
XFILLER_16_167 VGND VGND VPWR VPWR sky130_fd_sc_hd__fill_1
XFILLER_11_3 VGND VGND VPWR VPWR sky130_fd_sc_hd__decap_3
XFILLER_39_248 VGND VGND VPWR VPWR sky130_fd_sc_hd__decap_3
XFILLER_47_270 VGND VGND VPWR VPWR sky130_fd_sc_hd__decap_3
XFILLER_47_281 VGND VGND VPWR VPWR sky130_fd_sc_hd__decap_3
XFILLER_30_170 VGND VGND VPWR VPWR sky130_fd_sc_hd__fill_2
XPHY_EDGE_ROW_15_Left_64 VGND VGND VPWR VPWR sky130_fd_sc_hd__decap_3
XFILLER_26_78 VGND VGND VPWR VPWR sky130_fd_sc_hd__decap_3
XFILLER_13_137 VGND VGND VPWR VPWR sky130_fd_sc_hd__decap_3
XFILLER_42_66 VGND VGND VPWR VPWR sky130_fd_sc_hd__decap_3
XFILLER_9_108 VGND VGND VPWR VPWR sky130_fd_sc_hd__decap_3
XFILLER_3_38 VGND VGND VPWR VPWR sky130_fd_sc_hd__decap_3
XFILLER_29_281 VGND VGND VPWR VPWR sky130_fd_sc_hd__decap_3
XFILLER_44_251 VGND VGND VPWR VPWR sky130_fd_sc_hd__fill_1
XFILLER_44_262 VGND VGND VPWR VPWR sky130_fd_sc_hd__decap_3
X_0981_ _0987_/A _0987_/D VGND VGND VPWR VPWR _0981_/Y sky130_fd_sc_hd__nand2_2
XFILLER_12_181 VGND VGND VPWR VPWR sky130_fd_sc_hd__decap_3
XTAP_TAPCELL_ROW_14_176 VGND VPWR sky130_fd_sc_hd__tapvpwrvgnd_1
XFILLER_8_174 VGND VGND VPWR VPWR sky130_fd_sc_hd__fill_2
XFILLER_8_141 VGND VGND VPWR VPWR sky130_fd_sc_hd__decap_3
XFILLER_35_251 VGND VGND VPWR VPWR sky130_fd_sc_hd__decap_3
XFILLER_35_284 VGND VGND VPWR VPWR sky130_fd_sc_hd__fill_2
XPHY_EDGE_ROW_0_Left_49 VGND VGND VPWR VPWR sky130_fd_sc_hd__decap_3
XFILLER_37_55 VGND VGND VPWR VPWR sky130_fd_sc_hd__fill_1
XFILLER_26_284 VGND VGND VPWR VPWR sky130_fd_sc_hd__fill_2
XFILLER_41_243 VGND VGND VPWR VPWR sky130_fd_sc_hd__decap_3
XTAP_TAPCELL_ROW_28_246 VGND VPWR sky130_fd_sc_hd__tapvpwrvgnd_1
XFILLER_41_276 VGND VGND VPWR VPWR sky130_fd_sc_hd__decap_3
XFILLER_5_111 VGND VGND VPWR VPWR sky130_fd_sc_hd__fill_1
XFILLER_45_9 VGND VGND VPWR VPWR sky130_fd_sc_hd__decap_3
XFILLER_5_199 VGND VGND VPWR VPWR sky130_fd_sc_hd__decap_3
XFILLER_5_188 VGND VGND VPWR VPWR sky130_fd_sc_hd__fill_2
XFILLER_17_251 VGND VGND VPWR VPWR sky130_fd_sc_hd__decap_3
X_1180_ _1180_/A _1180_/B VGND VGND VPWR VPWR _1180_/Y sky130_fd_sc_hd__nor2_2
XTAP_TAPCELL_ROW_19_202 VGND VPWR sky130_fd_sc_hd__tapvpwrvgnd_1
XFILLER_17_284 VGND VGND VPWR VPWR sky130_fd_sc_hd__fill_2
XFILLER_32_243 VGND VGND VPWR VPWR sky130_fd_sc_hd__decap_3
X_0964_ _1029_/C _1023_/D VGND VGND VPWR VPWR _0964_/Y sky130_fd_sc_hd__nand2_2
X_0895_ _0888_/A _0890_/A _0810_/Y VGND VGND VPWR VPWR _0895_/Y sky130_fd_sc_hd__o21ai_2
XTAP_TAPCELL_ROW_2_114 VGND VPWR sky130_fd_sc_hd__tapvpwrvgnd_1
XFILLER_23_254 VGND VGND VPWR VPWR sky130_fd_sc_hd__decap_3
XFILLER_23_46 VGND VGND VPWR VPWR sky130_fd_sc_hd__decap_3
XFILLER_23_57 VGND VGND VPWR VPWR sky130_fd_sc_hd__decap_3
XTAP_TAPCELL_ROW_33_271 VGND VPWR sky130_fd_sc_hd__tapvpwrvgnd_1
XFILLER_48_43 VGND VGND VPWR VPWR sky130_fd_sc_hd__decap_3
XFILLER_0_39 VGND VGND VPWR VPWR sky130_fd_sc_hd__fill_1
XFILLER_48_65 VGND VGND VPWR VPWR sky130_fd_sc_hd__decap_3
XFILLER_9_15 VGND VGND VPWR VPWR sky130_fd_sc_hd__fill_2
XFILLER_13_90 VGND VGND VPWR VPWR sky130_fd_sc_hd__decap_3
XFILLER_43_6 VGND VGND VPWR VPWR sky130_fd_sc_hd__decap_3
X_0680_ _0680_/A _0680_/B VGND VGND VPWR VPWR _0683_/C sky130_fd_sc_hd__nand2_2
XFILLER_1_180 VGND VGND VPWR VPWR sky130_fd_sc_hd__fill_1
X_1232_ _1265_/Q _1231_/X _1117_/A VGND VGND VPWR VPWR _1232_/Y sky130_fd_sc_hd__a21oi_2
X_1301_ clkload5/A _1301_/D fanout66/X VGND VGND VPWR VPWR _1301_/Q sky130_fd_sc_hd__dfrtp_2
X_1094_ _1094_/A _1094_/B _1094_/C VGND VGND VPWR VPWR _1094_/Y sky130_fd_sc_hd__nand3_2
X_1163_ _1161_/Y _1242_/B _1242_/A VGND VGND VPWR VPWR _1165_/A sky130_fd_sc_hd__o21bai_4
XTAP_TAPCELL_ROW_47_341 VGND VPWR sky130_fd_sc_hd__tapvpwrvgnd_1
X_0947_ _0947_/A _0947_/B _0947_/C VGND VGND VPWR VPWR _0948_/A sky130_fd_sc_hd__nand3_4
X_0878_ _0787_/Y _0867_/X _0782_/Y VGND VGND VPWR VPWR _0879_/C sky130_fd_sc_hd__o21ai_4
XFILLER_18_24 VGND VGND VPWR VPWR sky130_fd_sc_hd__decap_3
XFILLER_18_35 VGND VGND VPWR VPWR sky130_fd_sc_hd__decap_3
XFILLER_11_279 VGND VGND VPWR VPWR sky130_fd_sc_hd__fill_1
Xclkload0 clkload0/A VGND VGND VPWR VPWR clkload0/X sky130_fd_sc_hd__clkbuf_4
XPHY_EDGE_ROW_3_Left_52 VGND VGND VPWR VPWR sky130_fd_sc_hd__decap_3
XFILLER_46_187 VGND VGND VPWR VPWR sky130_fd_sc_hd__decap_3
X_0801_ _0801_/A _0801_/B VGND VGND VPWR VPWR _0801_/Y sky130_fd_sc_hd__nand2_2
X_0732_ _1295_/Q VGND VGND VPWR VPWR _0985_/D sky130_fd_sc_hd__clkbuf_1
X_0663_ _0663_/A _0663_/B _0663_/C VGND VGND VPWR VPWR _0666_/B sky130_fd_sc_hd__nand3_2
XFILLER_1_60 VGND VGND VPWR VPWR sky130_fd_sc_hd__fill_1
XFILLER_1_82 VGND VGND VPWR VPWR sky130_fd_sc_hd__decap_3
XFILLER_37_154 VGND VGND VPWR VPWR sky130_fd_sc_hd__decap_3
X_1146_ _1137_/A _1145_/Y _1117_/A VGND VGND VPWR VPWR _1281_/D sky130_fd_sc_hd__a21oi_2
X_1215_ _1211_/C _1206_/Y _1214_/X VGND VGND VPWR VPWR _1221_/B sky130_fd_sc_hd__a21oi_4
X_1077_ _1071_/X _1073_/Y _1074_/X _1076_/X VGND VGND VPWR VPWR _1081_/D sky130_fd_sc_hd__o211ai_2
XFILLER_20_14 VGND VGND VPWR VPWR sky130_fd_sc_hd__decap_3
XFILLER_20_58 VGND VGND VPWR VPWR sky130_fd_sc_hd__fill_1
XFILLER_20_69 VGND VGND VPWR VPWR sky130_fd_sc_hd__decap_3
XPHY_EDGE_ROW_45_Left_94 VGND VGND VPWR VPWR sky130_fd_sc_hd__decap_3
XFILLER_43_102 VGND VGND VPWR VPWR sky130_fd_sc_hd__decap_3
XFILLER_45_55 VGND VGND VPWR VPWR sky130_fd_sc_hd__fill_1
XFILLER_3_220 VGND VGND VPWR VPWR sky130_fd_sc_hd__decap_3
XFILLER_3_231 VGND VGND VPWR VPWR sky130_fd_sc_hd__decap_3
XFILLER_6_27 VGND VGND VPWR VPWR sky130_fd_sc_hd__fill_1
XFILLER_19_110 VGND VGND VPWR VPWR sky130_fd_sc_hd__fill_2
X_1000_ _1003_/B _1049_/A _1047_/A VGND VGND VPWR VPWR _1001_/B sky130_fd_sc_hd__nand3_2
XFILLER_19_198 VGND VGND VPWR VPWR sky130_fd_sc_hd__decap_3
XFILLER_34_113 VGND VGND VPWR VPWR sky130_fd_sc_hd__decap_3
X_0715_ _0704_/X _0705_/X _0712_/Y _0765_/A VGND VGND VPWR VPWR _0718_/D sky130_fd_sc_hd__a22o_4
X_0646_ _1023_/A _0689_/A _1002_/A _0704_/A VGND VGND VPWR VPWR _0650_/B sky130_fd_sc_hd__a22oi_2
X_1129_ _1129_/A VGND VGND VPWR VPWR _1129_/Y sky130_fd_sc_hd__inv_2
XFILLER_31_57 VGND VGND VPWR VPWR sky130_fd_sc_hd__decap_3
Xoutput24 output24/A VGND VGND VPWR VPWR a_out[6] sky130_fd_sc_hd__clkdlybuf4s25_1
Xoutput46 _1302_/Q VGND VGND VPWR VPWR psum_out[4] sky130_fd_sc_hd__clkdlybuf4s25_1
Xoutput35 _1258_/Q VGND VGND VPWR VPWR psum_out[10] sky130_fd_sc_hd__clkdlybuf4s25_1
XFILLER_0_256 VGND VGND VPWR VPWR sky130_fd_sc_hd__decap_3
XFILLER_0_267 VGND VGND VPWR VPWR sky130_fd_sc_hd__decap_3
XFILLER_31_105 VGND VGND VPWR VPWR sky130_fd_sc_hd__decap_3
XFILLER_31_116 VGND VGND VPWR VPWR sky130_fd_sc_hd__decap_3
XPHY_EDGE_ROW_19_Right_19 VGND VGND VPWR VPWR sky130_fd_sc_hd__decap_3
Xclkbuf_3_1__f_clk clkbuf_0_clk/X VGND VGND VPWR VPWR clkload0/A sky130_fd_sc_hd__clkbuf_16
XPHY_EDGE_ROW_28_Right_28 VGND VGND VPWR VPWR sky130_fd_sc_hd__decap_3
XPHY_EDGE_ROW_37_Right_37 VGND VGND VPWR VPWR sky130_fd_sc_hd__decap_3
XFILLER_22_127 VGND VGND VPWR VPWR sky130_fd_sc_hd__decap_3
XFILLER_22_138 VGND VGND VPWR VPWR sky130_fd_sc_hd__fill_2
XPHY_EDGE_ROW_46_Right_46 VGND VGND VPWR VPWR sky130_fd_sc_hd__decap_3
X_0629_ _1191_/A VGND VGND VPWR VPWR _0630_/A sky130_fd_sc_hd__inv_2
XFILLER_13_116 VGND VGND VPWR VPWR sky130_fd_sc_hd__decap_3
XFILLER_13_149 VGND VGND VPWR VPWR sky130_fd_sc_hd__decap_3
XFILLER_38_271 VGND VGND VPWR VPWR sky130_fd_sc_hd__decap_3
XFILLER_42_78 VGND VGND VPWR VPWR sky130_fd_sc_hd__decap_3
XFILLER_44_230 VGND VGND VPWR VPWR sky130_fd_sc_hd__decap_3
XFILLER_44_274 VGND VGND VPWR VPWR sky130_fd_sc_hd__decap_3
X_0980_ _0916_/Y _0917_/Y _0921_/B VGND VGND VPWR VPWR _0987_/D sky130_fd_sc_hd__o21ai_2
XTAP_TAPCELL_ROW_14_177 VGND VPWR sky130_fd_sc_hd__tapvpwrvgnd_1
XPHY_EDGE_ROW_32_Left_81 VGND VGND VPWR VPWR sky130_fd_sc_hd__decap_3
XFILLER_8_197 VGND VGND VPWR VPWR sky130_fd_sc_hd__decap_3
XFILLER_8_153 VGND VGND VPWR VPWR sky130_fd_sc_hd__decap_3
XFILLER_8_131 VGND VGND VPWR VPWR sky130_fd_sc_hd__decap_3
XFILLER_35_274 VGND VGND VPWR VPWR sky130_fd_sc_hd__decap_3
XFILLER_12_15 VGND VGND VPWR VPWR sky130_fd_sc_hd__decap_3
XFILLER_12_37 VGND VGND VPWR VPWR sky130_fd_sc_hd__decap_3
XFILLER_5_9 VGND VGND VPWR VPWR sky130_fd_sc_hd__fill_1
XFILLER_37_12 VGND VGND VPWR VPWR sky130_fd_sc_hd__decap_3
XFILLER_37_34 VGND VGND VPWR VPWR sky130_fd_sc_hd__decap_3
XTAP_TAPCELL_ROW_28_247 VGND VPWR sky130_fd_sc_hd__tapvpwrvgnd_1
XFILLER_26_241 VGND VGND VPWR VPWR sky130_fd_sc_hd__decap_3
XFILLER_41_255 VGND VGND VPWR VPWR sky130_fd_sc_hd__decap_3
XTAP_TAPCELL_ROW_11_158 VGND VPWR sky130_fd_sc_hd__tapvpwrvgnd_1
XFILLER_5_156 VGND VGND VPWR VPWR sky130_fd_sc_hd__decap_3
XFILLER_38_9 VGND VGND VPWR VPWR sky130_fd_sc_hd__decap_3
XFILLER_32_200 VGND VGND VPWR VPWR sky130_fd_sc_hd__decap_3
XFILLER_32_277 VGND VGND VPWR VPWR sky130_fd_sc_hd__decap_3
X_0963_ _0960_/Y _0961_/Y _0962_/Y VGND VGND VPWR VPWR _0977_/B sky130_fd_sc_hd__a21o_2
X_0894_ _1023_/B _0894_/B VGND VGND VPWR VPWR _0894_/Y sky130_fd_sc_hd__nand2_2
XTAP_TAPCELL_ROW_2_115 VGND VPWR sky130_fd_sc_hd__tapvpwrvgnd_1
XFILLER_23_277 VGND VGND VPWR VPWR sky130_fd_sc_hd__decap_3
XTAP_TAPCELL_ROW_33_272 VGND VPWR sky130_fd_sc_hd__tapvpwrvgnd_1
XTAP_TAPCELL_ROW_25_228 VGND VPWR sky130_fd_sc_hd__tapvpwrvgnd_1
XFILLER_23_69 VGND VGND VPWR VPWR sky130_fd_sc_hd__fill_2
XFILLER_3_6 VGND VGND VPWR VPWR sky130_fd_sc_hd__decap_3
XFILLER_48_55 VGND VGND VPWR VPWR sky130_fd_sc_hd__fill_1
XFILLER_48_22 VGND VGND VPWR VPWR sky130_fd_sc_hd__decap_3
XFILLER_0_18 VGND VGND VPWR VPWR sky130_fd_sc_hd__fill_1
XFILLER_0_29 VGND VGND VPWR VPWR sky130_fd_sc_hd__fill_2
XFILLER_14_200 VGND VGND VPWR VPWR sky130_fd_sc_hd__decap_3
XFILLER_48_88 VGND VGND VPWR VPWR sky130_fd_sc_hd__decap_3
Xfanout70 fanout73/X VGND VGND VPWR VPWR fanout70/X sky130_fd_sc_hd__clkdlybuf4s25_1
XFILLER_36_6 VGND VGND VPWR VPWR sky130_fd_sc_hd__decap_3
X_1162_ _1301_/Q _1269_/Q VGND VGND VPWR VPWR _1242_/A sky130_fd_sc_hd__and2_2
X_1231_ _1224_/B _1225_/X _1147_/X _1264_/Q VGND VGND VPWR VPWR _1231_/X sky130_fd_sc_hd__o211a_2
X_1300_ clkload4/A _1300_/D wire65/X VGND VGND VPWR VPWR _1300_/Q sky130_fd_sc_hd__dfrtp_2
X_1093_ _1093_/A _1093_/B _1093_/C VGND VGND VPWR VPWR _1094_/A sky130_fd_sc_hd__nor3_2
XTAP_TAPCELL_ROW_47_342 VGND VPWR sky130_fd_sc_hd__tapvpwrvgnd_1
X_0946_ _0872_/Y _0939_/X _0948_/B VGND VGND VPWR VPWR _0946_/Y sky130_fd_sc_hd__o21ai_2
X_0877_ _0867_/X _0876_/Y _0872_/Y _0873_/Y VGND VGND VPWR VPWR _0880_/A sky130_fd_sc_hd__o22ai_2
XTAP_TAPCELL_ROW_30_253 VGND VPWR sky130_fd_sc_hd__tapvpwrvgnd_1
XFILLER_9_281 VGND VGND VPWR VPWR sky130_fd_sc_hd__decap_3
XFILLER_18_47 VGND VGND VPWR VPWR sky130_fd_sc_hd__decap_3
XFILLER_11_225 VGND VGND VPWR VPWR sky130_fd_sc_hd__decap_3
XFILLER_34_24 VGND VGND VPWR VPWR sky130_fd_sc_hd__decap_3
Xclkload1 clkload1/A VGND VGND VPWR VPWR clkload1/X sky130_fd_sc_hd__clkbuf_4
XFILLER_46_144 VGND VGND VPWR VPWR sky130_fd_sc_hd__fill_2
XTAP_TAPCELL_ROW_44_323 VGND VPWR sky130_fd_sc_hd__tapvpwrvgnd_1
X_0800_ _0740_/X _0796_/X _0797_/Y _0799_/Y VGND VGND VPWR VPWR _1272_/D sky130_fd_sc_hd__o31a_2
X_0731_ _0727_/Y _0787_/A _0730_/X VGND VGND VPWR VPWR _0735_/C sky130_fd_sc_hd__a21o_4
XFILLER_6_240 VGND VGND VPWR VPWR sky130_fd_sc_hd__decap_3
X_0662_ _0663_/C _0663_/A _0663_/B VGND VGND VPWR VPWR _0666_/A sky130_fd_sc_hd__a21o_2
XFILLER_37_133 VGND VGND VPWR VPWR sky130_fd_sc_hd__decap_3
XFILLER_37_166 VGND VGND VPWR VPWR sky130_fd_sc_hd__fill_2
X_1145_ _1142_/Y _1144_/Y _1139_/B VGND VGND VPWR VPWR _1145_/Y sky130_fd_sc_hd__o21bai_2
X_1214_ _1261_/Q _1279_/Q _1211_/X VGND VGND VPWR VPWR _1214_/X sky130_fd_sc_hd__a21o_2
X_1076_ _1035_/A _1035_/B _1038_/A _1075_/X VGND VGND VPWR VPWR _1076_/X sky130_fd_sc_hd__a31o_2
X_0929_ _0929_/A _0929_/B VGND VGND VPWR VPWR _0933_/A sky130_fd_sc_hd__nand2_2
XFILLER_28_100 VGND VGND VPWR VPWR sky130_fd_sc_hd__fill_2
XFILLER_28_122 VGND VGND VPWR VPWR sky130_fd_sc_hd__fill_2
XFILLER_29_46 VGND VGND VPWR VPWR sky130_fd_sc_hd__decap_3
XFILLER_29_57 VGND VGND VPWR VPWR sky130_fd_sc_hd__decap_3
XFILLER_29_79 VGND VGND VPWR VPWR sky130_fd_sc_hd__decap_3
XFILLER_28_188 VGND VGND VPWR VPWR sky130_fd_sc_hd__decap_3
XFILLER_43_158 VGND VGND VPWR VPWR sky130_fd_sc_hd__decap_3
XFILLER_43_169 VGND VGND VPWR VPWR sky130_fd_sc_hd__fill_2
XFILLER_45_12 VGND VGND VPWR VPWR sky130_fd_sc_hd__fill_1
XFILLER_6_39 VGND VGND VPWR VPWR sky130_fd_sc_hd__decap_3
XFILLER_10_70 VGND VGND VPWR VPWR sky130_fd_sc_hd__fill_1
XFILLER_19_155 VGND VGND VPWR VPWR sky130_fd_sc_hd__decap_3
XFILLER_34_158 VGND VGND VPWR VPWR sky130_fd_sc_hd__fill_1
X_0714_ _1098_/A _1044_/A _0711_/Y _0713_/Y VGND VGND VPWR VPWR _0765_/A sky130_fd_sc_hd__a22o_2
X_0645_ _0704_/A _1023_/A _0689_/A _1002_/A VGND VGND VPWR VPWR _0663_/B sky130_fd_sc_hd__and4_4
XFILLER_25_158 VGND VGND VPWR VPWR sky130_fd_sc_hd__decap_3
XFILLER_25_169 VGND VGND VPWR VPWR sky130_fd_sc_hd__fill_2
X_1128_ _1115_/A _1115_/C _1127_/Y VGND VGND VPWR VPWR _1139_/A sky130_fd_sc_hd__o21bai_4
X_1059_ _1052_/Y _1059_/B _1059_/C _1059_/D VGND VGND VPWR VPWR _1059_/Y sky130_fd_sc_hd__nand4b_4
XFILLER_40_139 VGND VGND VPWR VPWR sky130_fd_sc_hd__fill_1
Xoutput25 output25/A VGND VGND VPWR VPWR a_out[7] sky130_fd_sc_hd__clkdlybuf4s25_1
Xoutput47 _1303_/Q VGND VGND VPWR VPWR psum_out[5] sky130_fd_sc_hd__clkdlybuf4s25_1
Xoutput36 _1259_/Q VGND VGND VPWR VPWR psum_out[11] sky130_fd_sc_hd__clkdlybuf4s25_1
XFILLER_0_279 VGND VGND VPWR VPWR sky130_fd_sc_hd__fill_1
XFILLER_16_114 VGND VGND VPWR VPWR sky130_fd_sc_hd__decap_3
XFILLER_48_228 VGND VGND VPWR VPWR sky130_fd_sc_hd__decap_3
XFILLER_48_206 VGND VGND VPWR VPWR sky130_fd_sc_hd__decap_3
XFILLER_16_158 VGND VGND VPWR VPWR sky130_fd_sc_hd__decap_3
XFILLER_31_128 VGND VGND VPWR VPWR sky130_fd_sc_hd__decap_3
XFILLER_21_91 VGND VGND VPWR VPWR sky130_fd_sc_hd__fill_1
XFILLER_39_239 VGND VGND VPWR VPWR sky130_fd_sc_hd__decap_3
XFILLER_47_261 VGND VGND VPWR VPWR sky130_fd_sc_hd__decap_3
XFILLER_15_180 VGND VGND VPWR VPWR sky130_fd_sc_hd__decap_3
XFILLER_22_117 VGND VGND VPWR VPWR sky130_fd_sc_hd__fill_1
XFILLER_30_161 VGND VGND VPWR VPWR sky130_fd_sc_hd__decap_3
XFILLER_30_183 VGND VGND VPWR VPWR sky130_fd_sc_hd__fill_1
X_0628_ clear VGND VGND VPWR VPWR _0799_/A sky130_fd_sc_hd__clkbuf_1
XFILLER_38_250 VGND VGND VPWR VPWR sky130_fd_sc_hd__fill_2
XFILLER_13_128 VGND VGND VPWR VPWR sky130_fd_sc_hd__decap_3
XFILLER_38_283 VGND VGND VPWR VPWR sky130_fd_sc_hd__decap_3
XFILLER_21_150 VGND VGND VPWR VPWR sky130_fd_sc_hd__decap_3
XFILLER_21_172 VGND VGND VPWR VPWR sky130_fd_sc_hd__decap_3
XTAP_TAPCELL_ROW_8_143 VGND VPWR sky130_fd_sc_hd__tapvpwrvgnd_1
XFILLER_29_261 VGND VGND VPWR VPWR sky130_fd_sc_hd__fill_1
XFILLER_44_242 VGND VGND VPWR VPWR sky130_fd_sc_hd__decap_3
XFILLER_44_253 VGND VGND VPWR VPWR sky130_fd_sc_hd__decap_3
XFILLER_12_150 VGND VGND VPWR VPWR sky130_fd_sc_hd__fill_2
XFILLER_16_91 VGND VGND VPWR VPWR sky130_fd_sc_hd__decap_3
XFILLER_8_121 VGND VGND VPWR VPWR sky130_fd_sc_hd__fill_2
XFILLER_8_165 VGND VGND VPWR VPWR sky130_fd_sc_hd__decap_3
XFILLER_35_231 VGND VGND VPWR VPWR sky130_fd_sc_hd__decap_3
XFILLER_10_109 VGND VGND VPWR VPWR sky130_fd_sc_hd__decap_3
XFILLER_12_49 VGND VGND VPWR VPWR sky130_fd_sc_hd__decap_3
XFILLER_26_253 VGND VGND VPWR VPWR sky130_fd_sc_hd__decap_3
XFILLER_37_57 VGND VGND VPWR VPWR sky130_fd_sc_hd__decap_3
XFILLER_41_201 VGND VGND VPWR VPWR sky130_fd_sc_hd__decap_3
XFILLER_41_234 VGND VGND VPWR VPWR sky130_fd_sc_hd__decap_3
XFILLER_41_267 VGND VGND VPWR VPWR sky130_fd_sc_hd__decap_3
XTAP_TAPCELL_ROW_11_159 VGND VPWR sky130_fd_sc_hd__tapvpwrvgnd_1
XFILLER_17_242 VGND VGND VPWR VPWR sky130_fd_sc_hd__decap_3
XFILLER_32_234 VGND VGND VPWR VPWR sky130_fd_sc_hd__decap_3
X_0962_ _1024_/A _1023_/B _1070_/A _0967_/C split/X VGND VGND VPWR VPWR _0962_/Y sky130_fd_sc_hd__o2111ai_2
X_0893_ _0888_/Y _0891_/X _0892_/Y VGND VGND VPWR VPWR _0978_/A sky130_fd_sc_hd__o21bai_4
XFILLER_4_83 VGND VGND VPWR VPWR sky130_fd_sc_hd__fill_1
XFILLER_4_50 VGND VGND VPWR VPWR sky130_fd_sc_hd__fill_2
XTAP_TAPCELL_ROW_2_116 VGND VPWR sky130_fd_sc_hd__tapvpwrvgnd_1
XFILLER_23_15 VGND VGND VPWR VPWR sky130_fd_sc_hd__decap_3
XFILLER_23_245 VGND VGND VPWR VPWR sky130_fd_sc_hd__decap_3
XFILLER_23_37 VGND VGND VPWR VPWR sky130_fd_sc_hd__decap_3
XTAP_TAPCELL_ROW_25_229 VGND VPWR sky130_fd_sc_hd__tapvpwrvgnd_1
XFILLER_14_256 VGND VGND VPWR VPWR sky130_fd_sc_hd__decap_3
Xfanout71 fanout73/X VGND VGND VPWR VPWR wire72/A sky130_fd_sc_hd__clkdlybuf4s25_1
XFILLER_29_6 VGND VGND VPWR VPWR sky130_fd_sc_hd__decap_3
X_1092_ _1017_/X _1011_/Y _0951_/Y _0952_/Y VGND VGND VPWR VPWR _1094_/B sky130_fd_sc_hd__o22ai_2
X_1161_ _1159_/X _1158_/Y _1160_/Y VGND VGND VPWR VPWR _1161_/Y sky130_fd_sc_hd__a21boi_4
X_1230_ _1264_/Q _1228_/X _1229_/Y VGND VGND VPWR VPWR _1264_/D sky130_fd_sc_hd__o21a_2
X_0945_ _0945_/A _0945_/B _0945_/C VGND VGND VPWR VPWR _0948_/B sky130_fd_sc_hd__nand3_2
X_0876_ _0876_/A VGND VGND VPWR VPWR _0876_/Y sky130_fd_sc_hd__inv_2
XTAP_TAPCELL_ROW_30_254 VGND VPWR sky130_fd_sc_hd__tapvpwrvgnd_1
XFILLER_9_260 VGND VGND VPWR VPWR sky130_fd_sc_hd__decap_3
XFILLER_18_15 VGND VGND VPWR VPWR sky130_fd_sc_hd__decap_3
XFILLER_18_59 VGND VGND VPWR VPWR sky130_fd_sc_hd__decap_3
XFILLER_11_204 VGND VGND VPWR VPWR sky130_fd_sc_hd__decap_3
XFILLER_11_237 VGND VGND VPWR VPWR sky130_fd_sc_hd__decap_3
Xclkload2 clkload2/A VGND VGND VPWR VPWR clkload2/X sky130_fd_sc_hd__clkbuf_4
XTAP_TAPCELL_ROW_21_210 VGND VPWR sky130_fd_sc_hd__tapvpwrvgnd_1
XFILLER_7_208 VGND VGND VPWR VPWR sky130_fd_sc_hd__fill_1
XTAP_TAPCELL_ROW_44_324 VGND VPWR sky130_fd_sc_hd__tapvpwrvgnd_1
XFILLER_24_80 VGND VGND VPWR VPWR sky130_fd_sc_hd__decap_3
XFILLER_24_91 VGND VGND VPWR VPWR sky130_fd_sc_hd__decap_3
X_0730_ _0687_/A _0691_/X _0687_/B VGND VGND VPWR VPWR _0730_/X sky130_fd_sc_hd__o21a_2
X_0661_ _0689_/A _1098_/A _0660_/D _0660_/A VGND VGND VPWR VPWR _0663_/A sky130_fd_sc_hd__a22o_2
X_1213_ _1191_/B _1140_/A _1261_/Q _1210_/X _1212_/Y VGND VGND VPWR VPWR _1261_/D
+ sky130_fd_sc_hd__a32o_2
XFILLER_1_40 VGND VGND VPWR VPWR sky130_fd_sc_hd__decap_3
XFILLER_1_73 VGND VGND VPWR VPWR sky130_fd_sc_hd__decap_3
XFILLER_37_145 VGND VGND VPWR VPWR sky130_fd_sc_hd__decap_3
XFILLER_37_178 VGND VGND VPWR VPWR sky130_fd_sc_hd__fill_2
X_1144_ _1094_/Y _1143_/X _1127_/Y VGND VGND VPWR VPWR _1144_/Y sky130_fd_sc_hd__a21oi_2
X_1075_ _1075_/A _1075_/B _1120_/C _1104_/C VGND VGND VPWR VPWR _1075_/X sky130_fd_sc_hd__and4_2
X_0928_ _0928_/A _0928_/B _0928_/C VGND VGND VPWR VPWR _1010_/A sky130_fd_sc_hd__nand3_4
X_0859_ _0940_/A _0930_/B VGND VGND VPWR VPWR _0873_/A sky130_fd_sc_hd__and2_2
XFILLER_28_167 VGND VGND VPWR VPWR sky130_fd_sc_hd__fill_1
XFILLER_45_57 VGND VGND VPWR VPWR sky130_fd_sc_hd__decap_3
XFILLER_6_29 VGND VGND VPWR VPWR sky130_fd_sc_hd__decap_3
XFILLER_6_18 VGND VGND VPWR VPWR sky130_fd_sc_hd__decap_3
XFILLER_13_9 VGND VGND VPWR VPWR sky130_fd_sc_hd__decap_3
XFILLER_19_101 VGND VGND VPWR VPWR sky130_fd_sc_hd__fill_2
XFILLER_19_167 VGND VGND VPWR VPWR sky130_fd_sc_hd__fill_1
XFILLER_42_170 VGND VGND VPWR VPWR sky130_fd_sc_hd__decap_3
X_0713_ _0713_/A _0713_/B _0713_/C _0894_/B VGND VGND VPWR VPWR _0713_/Y sky130_fd_sc_hd__nand4_4
X_0644_ _1284_/Q VGND VGND VPWR VPWR _1002_/A sky130_fd_sc_hd__buf_2
XFILLER_15_27 VGND VGND VPWR VPWR sky130_fd_sc_hd__decap_3
X_1127_ _1125_/Y _1127_/B _1129_/A VGND VGND VPWR VPWR _1127_/Y sky130_fd_sc_hd__nand3b_2
X_1058_ _1058_/A _1058_/B VGND VGND VPWR VPWR _1059_/D sky130_fd_sc_hd__nand2_2
Xoutput26 output26/A VGND VGND VPWR VPWR b_out[0] sky130_fd_sc_hd__clkdlybuf4s25_1
Xoutput48 _1304_/Q VGND VGND VPWR VPWR psum_out[6] sky130_fd_sc_hd__clkdlybuf4s25_1
Xoutput37 _1260_/Q VGND VGND VPWR VPWR psum_out[12] sky130_fd_sc_hd__clkdlybuf4s25_1
XPHY_EDGE_ROW_1_Right_1 VGND VGND VPWR VPWR sky130_fd_sc_hd__decap_3
XFILLER_16_126 VGND VGND VPWR VPWR sky130_fd_sc_hd__decap_3
XFILLER_48_218 VGND VGND VPWR VPWR sky130_fd_sc_hd__decap_3
XFILLER_11_6 VGND VGND VPWR VPWR sky130_fd_sc_hd__decap_3
XFILLER_39_207 VGND VGND VPWR VPWR sky130_fd_sc_hd__decap_3
XFILLER_47_240 VGND VGND VPWR VPWR sky130_fd_sc_hd__decap_3
XFILLER_47_273 VGND VGND VPWR VPWR sky130_fd_sc_hd__decap_3
XFILLER_47_284 VGND VGND VPWR VPWR sky130_fd_sc_hd__fill_2
XFILLER_38_262 VGND VGND VPWR VPWR sky130_fd_sc_hd__decap_3
XFILLER_42_69 VGND VGND VPWR VPWR sky130_fd_sc_hd__decap_3
XTAP_TAPCELL_ROW_8_144 VGND VPWR sky130_fd_sc_hd__tapvpwrvgnd_1
XFILLER_29_240 VGND VGND VPWR VPWR sky130_fd_sc_hd__decap_3
XFILLER_29_284 VGND VGND VPWR VPWR sky130_fd_sc_hd__fill_2
XFILLER_44_265 VGND VGND VPWR VPWR sky130_fd_sc_hd__decap_3
XFILLER_12_184 VGND VGND VPWR VPWR sky130_fd_sc_hd__decap_3
XFILLER_16_81 VGND VGND VPWR VPWR sky130_fd_sc_hd__decap_3
XFILLER_8_144 VGND VGND VPWR VPWR sky130_fd_sc_hd__decap_3
XFILLER_8_100 VGND VGND VPWR VPWR sky130_fd_sc_hd__decap_3
XFILLER_35_221 VGND VGND VPWR VPWR sky130_fd_sc_hd__decap_3
XFILLER_35_265 VGND VGND VPWR VPWR sky130_fd_sc_hd__fill_1
XPHY_EDGE_ROW_19_Left_68 VGND VGND VPWR VPWR sky130_fd_sc_hd__decap_3
XFILLER_26_232 VGND VGND VPWR VPWR sky130_fd_sc_hd__decap_3
XFILLER_41_246 VGND VGND VPWR VPWR sky130_fd_sc_hd__decap_3
XFILLER_41_279 VGND VGND VPWR VPWR sky130_fd_sc_hd__fill_1
XFILLER_17_254 VGND VGND VPWR VPWR sky130_fd_sc_hd__decap_3
X_0961_ _1023_/B _1029_/C _0961_/C _0967_/C VGND VGND VPWR VPWR _0961_/Y sky130_fd_sc_hd__nand4_4
X_0892_ _1029_/C _0894_/B VGND VGND VPWR VPWR _0892_/Y sky130_fd_sc_hd__nand2_2
XFILLER_4_191 VGND VGND VPWR VPWR sky130_fd_sc_hd__decap_3
XFILLER_23_202 VGND VGND VPWR VPWR sky130_fd_sc_hd__decap_3
XTAP_TAPCELL_ROW_2_117 VGND VPWR sky130_fd_sc_hd__tapvpwrvgnd_1
XFILLER_23_257 VGND VGND VPWR VPWR sky130_fd_sc_hd__fill_2
XFILLER_23_49 VGND VGND VPWR VPWR sky130_fd_sc_hd__decap_3
XFILLER_48_68 VGND VGND VPWR VPWR sky130_fd_sc_hd__decap_3
XFILLER_48_46 VGND VGND VPWR VPWR sky130_fd_sc_hd__decap_3
XFILLER_13_93 VGND VGND VPWR VPWR sky130_fd_sc_hd__decap_3
XFILLER_1_172 VGND VGND VPWR VPWR sky130_fd_sc_hd__decap_3
XFILLER_43_9 VGND VGND VPWR VPWR sky130_fd_sc_hd__decap_3
X_1091_ _1063_/Y _1064_/Y _1093_/B _1140_/A VGND VGND VPWR VPWR _1091_/X sky130_fd_sc_hd__o31a_2
X_1160_ _1300_/Q _1268_/Q VGND VGND VPWR VPWR _1160_/Y sky130_fd_sc_hd__nand2_2
Xclkbuf_3_7__f_clk clkbuf_0_clk/X VGND VGND VPWR VPWR clkload5/A sky130_fd_sc_hd__clkbuf_16
X_0944_ _1010_/A _1007_/A _1007_/B VGND VGND VPWR VPWR _0945_/C sky130_fd_sc_hd__nand3_2
X_0875_ _0872_/Y _0873_/Y _0785_/Y _0876_/A VGND VGND VPWR VPWR _0875_/X sky130_fd_sc_hd__o211a_4
XTAP_TAPCELL_ROW_30_255 VGND VPWR sky130_fd_sc_hd__tapvpwrvgnd_1
XFILLER_9_272 VGND VGND VPWR VPWR sky130_fd_sc_hd__decap_3
XFILLER_18_27 VGND VGND VPWR VPWR sky130_fd_sc_hd__fill_1
XFILLER_18_38 VGND VGND VPWR VPWR sky130_fd_sc_hd__decap_3
X_1289_ clkload3/A input8/X wire72/X VGND VGND VPWR VPWR _1289_/Q sky130_fd_sc_hd__dfrtp_2
XFILLER_11_216 VGND VGND VPWR VPWR sky130_fd_sc_hd__decap_3
Xclkload3 clkload3/A VGND VGND VPWR VPWR clkload3/X sky130_fd_sc_hd__clkbuf_4
XTAP_TAPCELL_ROW_21_211 VGND VPWR sky130_fd_sc_hd__tapvpwrvgnd_1
XTAP_TAPCELL_ROW_44_325 VGND VPWR sky130_fd_sc_hd__tapvpwrvgnd_1
XFILLER_10_282 VGND VGND VPWR VPWR sky130_fd_sc_hd__decap_3
X_0660_ _0660_/A _1098_/A _0689_/A _0660_/D VGND VGND VPWR VPWR _0663_/C sky130_fd_sc_hd__nand4_2
XFILLER_6_253 VGND VGND VPWR VPWR sky130_fd_sc_hd__decap_3
XFILLER_6_231 VGND VGND VPWR VPWR sky130_fd_sc_hd__decap_3
XFILLER_37_113 VGND VGND VPWR VPWR sky130_fd_sc_hd__fill_2
XFILLER_37_124 VGND VGND VPWR VPWR sky130_fd_sc_hd__decap_3
X_1212_ _1210_/B _1211_/C _1211_/X _0799_/A _1191_/B VGND VGND VPWR VPWR _1212_/Y
+ sky130_fd_sc_hd__a2111oi_2
XFILLER_1_85 VGND VGND VPWR VPWR sky130_fd_sc_hd__decap_3
XFILLER_37_157 VGND VGND VPWR VPWR sky130_fd_sc_hd__decap_3
X_1143_ _1063_/Y _1064_/Y _1093_/B _1090_/B VGND VGND VPWR VPWR _1143_/X sky130_fd_sc_hd__o31a_2
X_1074_ _1071_/X _1072_/Y _1104_/C _1101_/A VGND VGND VPWR VPWR _1074_/X sky130_fd_sc_hd__a2bb2o_2
X_0927_ _0914_/Y _0919_/Y _1004_/A _0929_/B VGND VGND VPWR VPWR _0928_/A sky130_fd_sc_hd__o211ai_2
XFILLER_20_17 VGND VGND VPWR VPWR sky130_fd_sc_hd__fill_2
XFILLER_20_39 VGND VGND VPWR VPWR sky130_fd_sc_hd__decap_3
X_0858_ _0855_/Y _0856_/Y _0857_/X _0847_/Y VGND VGND VPWR VPWR _0873_/C sky130_fd_sc_hd__o211a_2
X_0789_ _1002_/A _0814_/A _0718_/A _0718_/D _0769_/X VGND VGND VPWR VPWR _0789_/X
+ sky130_fd_sc_hd__a41o_2
XFILLER_43_105 VGND VGND VPWR VPWR sky130_fd_sc_hd__decap_3
XFILLER_43_149 VGND VGND VPWR VPWR sky130_fd_sc_hd__decap_3
XPHY_EDGE_ROW_7_Left_56 VGND VGND VPWR VPWR sky130_fd_sc_hd__decap_3
XFILLER_3_223 VGND VGND VPWR VPWR sky130_fd_sc_hd__fill_1
XFILLER_3_234 VGND VGND VPWR VPWR sky130_fd_sc_hd__fill_2
XFILLER_19_70 VGND VGND VPWR VPWR sky130_fd_sc_hd__decap_3
XFILLER_19_92 VGND VGND VPWR VPWR sky130_fd_sc_hd__fill_1
X_0712_ _0712_/A _0712_/B VGND VGND VPWR VPWR _0712_/Y sky130_fd_sc_hd__nand2_4
X_0643_ _1140_/A _0643_/B _0643_/C VGND VGND VPWR VPWR _1267_/D sky130_fd_sc_hd__and3_2
X_1126_ _1104_/X _1108_/B _1121_/X _1123_/Y _1106_/B VGND VGND VPWR VPWR _1129_/A
+ sky130_fd_sc_hd__o2111ai_2
X_1057_ _1055_/Y _0938_/X _1056_/Y VGND VGND VPWR VPWR _1059_/B sky130_fd_sc_hd__o21ai_4
Xoutput27 output27/A VGND VGND VPWR VPWR b_out[1] sky130_fd_sc_hd__clkdlybuf4s25_1
Xoutput49 _1305_/Q VGND VGND VPWR VPWR psum_out[7] sky130_fd_sc_hd__clkdlybuf4s25_1
Xoutput38 _1261_/Q VGND VGND VPWR VPWR psum_out[13] sky130_fd_sc_hd__clkdlybuf4s25_1
XFILLER_31_108 VGND VGND VPWR VPWR sky130_fd_sc_hd__decap_3
XFILLER_31_119 VGND VGND VPWR VPWR sky130_fd_sc_hd__decap_3
XFILLER_47_252 VGND VGND VPWR VPWR sky130_fd_sc_hd__decap_3
Xclkbuf_0_clk clk VGND VGND VPWR VPWR clkbuf_0_clk/X sky130_fd_sc_hd__clkbuf_16
XTAP_TAPCELL_ROW_17_188 VGND VPWR sky130_fd_sc_hd__tapvpwrvgnd_1
XFILLER_7_51 VGND VGND VPWR VPWR sky130_fd_sc_hd__decap_3
XPHY_EDGE_ROW_15_Right_15 VGND VGND VPWR VPWR sky130_fd_sc_hd__decap_3
XFILLER_26_27 VGND VGND VPWR VPWR sky130_fd_sc_hd__fill_1
XFILLER_38_241 VGND VGND VPWR VPWR sky130_fd_sc_hd__decap_3
XFILLER_38_274 VGND VGND VPWR VPWR sky130_fd_sc_hd__decap_3
X_1109_ _1083_/A _1083_/D _1083_/B VGND VGND VPWR VPWR _1109_/Y sky130_fd_sc_hd__a21boi_2
XPHY_EDGE_ROW_24_Right_24 VGND VGND VPWR VPWR sky130_fd_sc_hd__decap_3
XFILLER_13_119 VGND VGND VPWR VPWR sky130_fd_sc_hd__decap_3
XTAP_TAPCELL_ROW_8_145 VGND VPWR sky130_fd_sc_hd__tapvpwrvgnd_1
XPHY_EDGE_ROW_33_Right_33 VGND VGND VPWR VPWR sky130_fd_sc_hd__decap_3
XFILLER_16_60 VGND VGND VPWR VPWR sky130_fd_sc_hd__decap_3
XFILLER_44_233 VGND VGND VPWR VPWR sky130_fd_sc_hd__decap_3
XFILLER_44_277 VGND VGND VPWR VPWR sky130_fd_sc_hd__decap_3
XPHY_EDGE_ROW_42_Right_42 VGND VGND VPWR VPWR sky130_fd_sc_hd__decap_3
XFILLER_12_141 VGND VGND VPWR VPWR sky130_fd_sc_hd__decap_3
XFILLER_32_81 VGND VGND VPWR VPWR sky130_fd_sc_hd__decap_3
XFILLER_8_156 VGND VGND VPWR VPWR sky130_fd_sc_hd__decap_3
XFILLER_8_134 VGND VGND VPWR VPWR sky130_fd_sc_hd__decap_3
XFILLER_35_244 VGND VGND VPWR VPWR sky130_fd_sc_hd__fill_2
XFILLER_12_18 VGND VGND VPWR VPWR sky130_fd_sc_hd__decap_3
XFILLER_35_277 VGND VGND VPWR VPWR sky130_fd_sc_hd__decap_3
XFILLER_37_37 VGND VGND VPWR VPWR sky130_fd_sc_hd__decap_3
XFILLER_26_200 VGND VGND VPWR VPWR sky130_fd_sc_hd__decap_3
XFILLER_26_244 VGND VGND VPWR VPWR sky130_fd_sc_hd__decap_3
XFILLER_41_225 VGND VGND VPWR VPWR sky130_fd_sc_hd__decap_3
XTAP_TAPCELL_ROW_36_283 VGND VPWR sky130_fd_sc_hd__tapvpwrvgnd_1
XFILLER_41_258 VGND VGND VPWR VPWR sky130_fd_sc_hd__decap_3
XFILLER_5_126 VGND VGND VPWR VPWR sky130_fd_sc_hd__decap_3
XPHY_EDGE_ROW_36_Left_85 VGND VGND VPWR VPWR sky130_fd_sc_hd__decap_3
XFILLER_5_159 VGND VGND VPWR VPWR sky130_fd_sc_hd__decap_3
XFILLER_17_211 VGND VGND VPWR VPWR sky130_fd_sc_hd__fill_1
XFILLER_17_233 VGND VGND VPWR VPWR sky130_fd_sc_hd__decap_3
XPHY_EDGE_ROW_20_Left_69 VGND VGND VPWR VPWR sky130_fd_sc_hd__decap_3
XFILLER_32_203 VGND VGND VPWR VPWR sky130_fd_sc_hd__decap_3
X_0960_ _0960_/A _0960_/B VGND VGND VPWR VPWR _0960_/Y sky130_fd_sc_hd__nand2_2
X_0891_ _0890_/A _0889_/Y _0890_/Y VGND VGND VPWR VPWR _0891_/X sky130_fd_sc_hd__o21a_2
XFILLER_4_63 VGND VGND VPWR VPWR sky130_fd_sc_hd__fill_1
XFILLER_23_225 VGND VGND VPWR VPWR sky130_fd_sc_hd__decap_3
XFILLER_2_129 VGND VGND VPWR VPWR sky130_fd_sc_hd__decap_3
XFILLER_3_9 VGND VGND VPWR VPWR sky130_fd_sc_hd__decap_3
XFILLER_48_25 VGND VGND VPWR VPWR sky130_fd_sc_hd__decap_3
XFILLER_14_203 VGND VGND VPWR VPWR sky130_fd_sc_hd__decap_3
Xfanout73 input17/X VGND VGND VPWR VPWR fanout73/X sky130_fd_sc_hd__clkdlybuf4s25_1
XFILLER_38_80 VGND VGND VPWR VPWR sky130_fd_sc_hd__decap_3
XFILLER_38_91 VGND VGND VPWR VPWR sky130_fd_sc_hd__decap_3
X_1090_ _1090_/A _1090_/B VGND VGND VPWR VPWR _1093_/B sky130_fd_sc_hd__nand2_4
X_0943_ _0847_/Y _0857_/X _0856_/Y _0855_/Y VGND VGND VPWR VPWR _1007_/B sky130_fd_sc_hd__o2bb2ai_2
X_0874_ _0781_/Y _0792_/A _0792_/B _0787_/B _0787_/A VGND VGND VPWR VPWR _0876_/A
+ sky130_fd_sc_hd__a32o_2
XTAP_TAPCELL_ROW_30_256 VGND VPWR sky130_fd_sc_hd__tapvpwrvgnd_1
XFILLER_9_284 VGND VGND VPWR VPWR sky130_fd_sc_hd__fill_2
X_1288_ _1291_/CLK input7/X wire72/X VGND VGND VPWR VPWR _1288_/Q sky130_fd_sc_hd__dfrtp_2
XFILLER_11_228 VGND VGND VPWR VPWR sky130_fd_sc_hd__decap_3
XFILLER_34_27 VGND VGND VPWR VPWR sky130_fd_sc_hd__fill_1
Xclkload4 clkload4/A VGND VGND VPWR VPWR clkload4/X sky130_fd_sc_hd__clkbuf_4
XTAP_TAPCELL_ROW_21_212 VGND VPWR sky130_fd_sc_hd__tapvpwrvgnd_1
XTAP_TAPCELL_ROW_44_326 VGND VPWR sky130_fd_sc_hd__tapvpwrvgnd_1
XFILLER_24_71 VGND VGND VPWR VPWR sky130_fd_sc_hd__decap_3
XFILLER_6_243 VGND VGND VPWR VPWR sky130_fd_sc_hd__decap_3
XFILLER_1_31 VGND VGND VPWR VPWR sky130_fd_sc_hd__decap_3
XFILLER_37_136 VGND VGND VPWR VPWR sky130_fd_sc_hd__decap_3
X_1142_ _1142_/A VGND VGND VPWR VPWR _1142_/Y sky130_fd_sc_hd__inv_2
X_1211_ _1260_/Q _1278_/Q _1211_/C VGND VGND VPWR VPWR _1211_/X sky130_fd_sc_hd__and3_2
XFILLER_37_169 VGND VGND VPWR VPWR sky130_fd_sc_hd__decap_3
X_1073_ _1072_/Y _1101_/A _1104_/C VGND VGND VPWR VPWR _1073_/Y sky130_fd_sc_hd__nand3b_2
XPHY_EDGE_ROW_23_Left_72 VGND VGND VPWR VPWR sky130_fd_sc_hd__decap_3
X_0926_ _0854_/A _0854_/B _0844_/A _0839_/Y VGND VGND VPWR VPWR _0929_/B sky130_fd_sc_hd__a22o_4
X_0857_ _0774_/A _0774_/B _0774_/C _0783_/C _0783_/A VGND VGND VPWR VPWR _0857_/X
+ sky130_fd_sc_hd__a32o_2
XFILLER_29_49 VGND VGND VPWR VPWR sky130_fd_sc_hd__decap_3
X_0788_ _0782_/Y _0785_/Y _0787_/Y VGND VGND VPWR VPWR _0788_/Y sky130_fd_sc_hd__a21oi_2
XFILLER_3_202 VGND VGND VPWR VPWR sky130_fd_sc_hd__decap_3
XFILLER_19_158 VGND VGND VPWR VPWR sky130_fd_sc_hd__decap_3
XFILLER_27_180 VGND VGND VPWR VPWR sky130_fd_sc_hd__fill_1
XFILLER_35_81 VGND VGND VPWR VPWR sky130_fd_sc_hd__fill_2
XFILLER_42_161 VGND VGND VPWR VPWR sky130_fd_sc_hd__decap_3
X_0711_ _0711_/A _0711_/B VGND VGND VPWR VPWR _0711_/Y sky130_fd_sc_hd__nand2_4
XFILLER_32_3 VGND VGND VPWR VPWR sky130_fd_sc_hd__decap_3
X_0642_ _0704_/A _0642_/B _1023_/A _0642_/D VGND VGND VPWR VPWR _0643_/C sky130_fd_sc_hd__nand4_2
X_1125_ _1121_/X _1123_/Y _1124_/X VGND VGND VPWR VPWR _1125_/Y sky130_fd_sc_hd__a21oi_2
XFILLER_18_180 VGND VGND VPWR VPWR sky130_fd_sc_hd__decap_3
XFILLER_33_161 VGND VGND VPWR VPWR sky130_fd_sc_hd__fill_2
X_1056_ _0948_/A _0948_/B _0939_/X _1056_/B2 VGND VGND VPWR VPWR _1056_/Y sky130_fd_sc_hd__o2bb2ai_2
Xoutput28 _1292_/Q VGND VGND VPWR VPWR b_out[2] sky130_fd_sc_hd__clkdlybuf4s25_1
Xoutput39 _1262_/Q VGND VGND VPWR VPWR psum_out[14] sky130_fd_sc_hd__clkdlybuf4s25_1
X_0909_ _0909_/A _0909_/B VGND VGND VPWR VPWR _0990_/B sky130_fd_sc_hd__nand2_4
XFILLER_48_209 VGND VGND VPWR VPWR sky130_fd_sc_hd__decap_3
XFILLER_16_117 VGND VGND VPWR VPWR sky130_fd_sc_hd__decap_3
XFILLER_47_231 VGND VGND VPWR VPWR sky130_fd_sc_hd__decap_3
XFILLER_47_264 VGND VGND VPWR VPWR sky130_fd_sc_hd__decap_3
XFILLER_15_183 VGND VGND VPWR VPWR sky130_fd_sc_hd__decap_3
XFILLER_30_164 VGND VGND VPWR VPWR sky130_fd_sc_hd__decap_3
XTAP_TAPCELL_ROW_17_189 VGND VPWR sky130_fd_sc_hd__tapvpwrvgnd_1
XFILLER_7_30 VGND VGND VPWR VPWR sky130_fd_sc_hd__decap_3
XFILLER_13_109 VGND VGND VPWR VPWR sky130_fd_sc_hd__decap_3
XFILLER_26_39 VGND VGND VPWR VPWR sky130_fd_sc_hd__decap_3
XFILLER_38_253 VGND VGND VPWR VPWR sky130_fd_sc_hd__decap_3
X_1108_ _1108_/A _1108_/B VGND VGND VPWR VPWR _1111_/A sky130_fd_sc_hd__xnor2_2
X_1039_ _1081_/C _1036_/D _1037_/Y _1038_/Y VGND VGND VPWR VPWR _1039_/Y sky130_fd_sc_hd__a22oi_2
XFILLER_21_153 VGND VGND VPWR VPWR sky130_fd_sc_hd__fill_2
XFILLER_21_175 VGND VGND VPWR VPWR sky130_fd_sc_hd__decap_3
XTAP_TAPCELL_ROW_8_146 VGND VPWR sky130_fd_sc_hd__tapvpwrvgnd_1
XFILLER_12_131 VGND VGND VPWR VPWR sky130_fd_sc_hd__decap_3
XFILLER_16_94 VGND VGND VPWR VPWR sky130_fd_sc_hd__fill_2
XFILLER_44_245 VGND VGND VPWR VPWR sky130_fd_sc_hd__decap_3
XFILLER_44_256 VGND VGND VPWR VPWR sky130_fd_sc_hd__decap_3
XFILLER_12_197 VGND VGND VPWR VPWR sky130_fd_sc_hd__decap_3
XFILLER_8_168 VGND VGND VPWR VPWR sky130_fd_sc_hd__decap_3
XFILLER_35_234 VGND VGND VPWR VPWR sky130_fd_sc_hd__decap_3
XTAP_TAPCELL_ROW_13_170 VGND VPWR sky130_fd_sc_hd__tapvpwrvgnd_1
XFILLER_7_190 VGND VGND VPWR VPWR sky130_fd_sc_hd__decap_3
XFILLER_26_212 VGND VGND VPWR VPWR sky130_fd_sc_hd__decap_3
XFILLER_37_49 VGND VGND VPWR VPWR sky130_fd_sc_hd__decap_3
XFILLER_26_278 VGND VGND VPWR VPWR sky130_fd_sc_hd__decap_3
XFILLER_41_204 VGND VGND VPWR VPWR sky130_fd_sc_hd__fill_2
XFILLER_41_237 VGND VGND VPWR VPWR sky130_fd_sc_hd__decap_3
XTAP_TAPCELL_ROW_36_284 VGND VPWR sky130_fd_sc_hd__tapvpwrvgnd_1
XFILLER_5_105 VGND VGND VPWR VPWR sky130_fd_sc_hd__decap_3
XFILLER_17_245 VGND VGND VPWR VPWR sky130_fd_sc_hd__decap_3
XTAP_TAPCELL_ROW_27_240 VGND VPWR sky130_fd_sc_hd__tapvpwrvgnd_1
XFILLER_32_237 VGND VGND VPWR VPWR sky130_fd_sc_hd__decap_3
XFILLER_43_81 VGND VGND VPWR VPWR sky130_fd_sc_hd__decap_3
X_0890_ _0890_/A _0890_/B VGND VGND VPWR VPWR _0890_/Y sky130_fd_sc_hd__nand2_2
XFILLER_4_182 VGND VGND VPWR VPWR sky130_fd_sc_hd__decap_3
XFILLER_23_18 VGND VGND VPWR VPWR sky130_fd_sc_hd__decap_3
XFILLER_23_248 VGND VGND VPWR VPWR sky130_fd_sc_hd__decap_3
XFILLER_31_281 VGND VGND VPWR VPWR sky130_fd_sc_hd__decap_3
XFILLER_48_37 VGND VGND VPWR VPWR sky130_fd_sc_hd__decap_3
XFILLER_13_51 VGND VGND VPWR VPWR sky130_fd_sc_hd__fill_2
XFILLER_14_215 VGND VGND VPWR VPWR sky130_fd_sc_hd__fill_1
XFILLER_14_259 VGND VGND VPWR VPWR sky130_fd_sc_hd__decap_3
XFILLER_13_84 VGND VGND VPWR VPWR sky130_fd_sc_hd__decap_3
XFILLER_29_9 VGND VGND VPWR VPWR sky130_fd_sc_hd__fill_2
XTAP_TAPCELL_ROW_0_98 VGND VPWR sky130_fd_sc_hd__tapvpwrvgnd_1
XFILLER_13_281 VGND VGND VPWR VPWR sky130_fd_sc_hd__decap_3
X_0942_ _0942_/A _0942_/B VGND VGND VPWR VPWR _0945_/B sky130_fd_sc_hd__nand2_2
X_0873_ _0873_/A _0873_/B _0873_/C VGND VGND VPWR VPWR _0873_/Y sky130_fd_sc_hd__nor3_2
XTAP_TAPCELL_ROW_30_257 VGND VPWR sky130_fd_sc_hd__tapvpwrvgnd_1
XFILLER_9_263 VGND VGND VPWR VPWR sky130_fd_sc_hd__decap_3
XFILLER_18_18 VGND VGND VPWR VPWR sky130_fd_sc_hd__decap_3
XFILLER_18_29 VGND VGND VPWR VPWR sky130_fd_sc_hd__decap_3
X_1287_ _1291_/CLK input6/X wire72/X VGND VGND VPWR VPWR _1287_/Q sky130_fd_sc_hd__dfrtp_2
Xclkload5 clkload5/A VGND VGND VPWR VPWR clkload5/X sky130_fd_sc_hd__clkbuf_4
XTAP_TAPCELL_ROW_44_327 VGND VPWR sky130_fd_sc_hd__tapvpwrvgnd_1
XFILLER_24_50 VGND VGND VPWR VPWR sky130_fd_sc_hd__decap_3
XFILLER_24_83 VGND VGND VPWR VPWR sky130_fd_sc_hd__fill_1
XFILLER_24_94 VGND VGND VPWR VPWR sky130_fd_sc_hd__decap_3
XFILLER_6_200 VGND VGND VPWR VPWR sky130_fd_sc_hd__decap_3
XFILLER_40_82 VGND VGND VPWR VPWR sky130_fd_sc_hd__fill_2
XFILLER_6_277 VGND VGND VPWR VPWR sky130_fd_sc_hd__fill_1
XFILLER_1_43 VGND VGND VPWR VPWR sky130_fd_sc_hd__decap_3
XFILLER_1_76 VGND VGND VPWR VPWR sky130_fd_sc_hd__decap_3
XFILLER_37_148 VGND VGND VPWR VPWR sky130_fd_sc_hd__decap_3
X_1141_ _1141_/A _1141_/B VGND VGND VPWR VPWR _1280_/D sky130_fd_sc_hd__nor2_2
X_1210_ _1210_/A _1210_/B _1211_/C VGND VGND VPWR VPWR _1210_/X sky130_fd_sc_hd__or3_2
X_1072_ _1295_/Q _1070_/A _1120_/A _1071_/B VGND VGND VPWR VPWR _1072_/Y sky130_fd_sc_hd__a22oi_2
X_0925_ _0885_/X _0886_/Y _0929_/A VGND VGND VPWR VPWR _0928_/B sky130_fd_sc_hd__o21ai_2
X_0856_ _0846_/A _0922_/B _0848_/Y VGND VGND VPWR VPWR _0856_/Y sky130_fd_sc_hd__o21ai_4
X_0787_ _0787_/A _0787_/B VGND VGND VPWR VPWR _0787_/Y sky130_fd_sc_hd__nand2_4
XFILLER_36_170 VGND VGND VPWR VPWR sky130_fd_sc_hd__decap_3
XTAP_TAPCELL_ROW_41_308 VGND VPWR sky130_fd_sc_hd__tapvpwrvgnd_1
XFILLER_3_225 VGND VGND VPWR VPWR sky130_fd_sc_hd__decap_3
XFILLER_35_60 VGND VGND VPWR VPWR sky130_fd_sc_hd__decap_3
XFILLER_42_173 VGND VGND VPWR VPWR sky130_fd_sc_hd__decap_3
X_0710_ _0811_/B _0742_/B VGND VGND VPWR VPWR _0711_/B sky130_fd_sc_hd__nand2_2
X_0641_ _0642_/B _1023_/A _0642_/D _0704_/A VGND VGND VPWR VPWR _0643_/B sky130_fd_sc_hd__a22o_2
XFILLER_25_3 VGND VGND VPWR VPWR sky130_fd_sc_hd__decap_3
XFILLER_18_192 VGND VGND VPWR VPWR sky130_fd_sc_hd__decap_3
X_1124_ _1104_/X _1108_/B _1106_/B VGND VGND VPWR VPWR _1124_/X sky130_fd_sc_hd__o21a_2
X_1055_ _1053_/Y _1054_/X _0949_/Y VGND VGND VPWR VPWR _1055_/Y sky130_fd_sc_hd__o21ai_4
Xoutput18 _1282_/Q VGND VGND VPWR VPWR a_out[0] sky130_fd_sc_hd__clkdlybuf4s25_1
Xoutput29 _1293_/Q VGND VGND VPWR VPWR b_out[3] sky130_fd_sc_hd__clkdlybuf4s25_1
X_0908_ _0905_/Y _0906_/X _0973_/B VGND VGND VPWR VPWR _0909_/A sky130_fd_sc_hd__o21ai_2
X_0839_ _0885_/C _0885_/B _0885_/A VGND VGND VPWR VPWR _0839_/Y sky130_fd_sc_hd__nand3_4
XFILLER_16_129 VGND VGND VPWR VPWR sky130_fd_sc_hd__decap_3
XFILLER_21_73 VGND VGND VPWR VPWR sky130_fd_sc_hd__decap_3
XFILLER_11_9 VGND VGND VPWR VPWR sky130_fd_sc_hd__decap_3
XFILLER_47_221 VGND VGND VPWR VPWR sky130_fd_sc_hd__decap_3
XFILLER_47_243 VGND VGND VPWR VPWR sky130_fd_sc_hd__decap_3
XFILLER_47_276 VGND VGND VPWR VPWR sky130_fd_sc_hd__decap_3
Xmax_cap60 _0985_/D VGND VGND VPWR VPWR _1120_/C sky130_fd_sc_hd__clkbuf_2
XFILLER_15_162 VGND VGND VPWR VPWR sky130_fd_sc_hd__decap_3
XFILLER_30_132 VGND VGND VPWR VPWR sky130_fd_sc_hd__decap_3
Xsplit split/A VGND VGND VPWR VPWR split/X sky130_fd_sc_hd__buf_4
XFILLER_7_42 VGND VGND VPWR VPWR sky130_fd_sc_hd__decap_3
XFILLER_38_210 VGND VGND VPWR VPWR sky130_fd_sc_hd__decap_3
XFILLER_38_232 VGND VGND VPWR VPWR sky130_fd_sc_hd__decap_3
XFILLER_38_265 VGND VGND VPWR VPWR sky130_fd_sc_hd__decap_3
X_1107_ _1071_/X _1073_/Y _1074_/X _1076_/X VGND VGND VPWR VPWR _1108_/B sky130_fd_sc_hd__a2bb2o_2
X_1038_ _1038_/A _1038_/B VGND VGND VPWR VPWR _1038_/Y sky130_fd_sc_hd__nand2_2
XPHY_EDGE_ROW_5_Right_5 VGND VGND VPWR VPWR sky130_fd_sc_hd__decap_3
XTAP_TAPCELL_ROW_8_147 VGND VPWR sky130_fd_sc_hd__tapvpwrvgnd_1
XFILLER_29_210 VGND VGND VPWR VPWR sky130_fd_sc_hd__decap_3
XFILLER_29_243 VGND VGND VPWR VPWR sky130_fd_sc_hd__fill_2
XFILLER_29_276 VGND VGND VPWR VPWR sky130_fd_sc_hd__decap_3
XFILLER_44_224 VGND VGND VPWR VPWR sky130_fd_sc_hd__decap_3
XFILLER_44_268 VGND VGND VPWR VPWR sky130_fd_sc_hd__decap_3
XFILLER_8_103 VGND VGND VPWR VPWR sky130_fd_sc_hd__decap_3
XFILLER_32_94 VGND VGND VPWR VPWR sky130_fd_sc_hd__decap_3
XFILLER_8_147 VGND VGND VPWR VPWR sky130_fd_sc_hd__decap_3
XTAP_TAPCELL_ROW_13_171 VGND VPWR sky130_fd_sc_hd__tapvpwrvgnd_1
XTAP_TAPCELL_ROW_5_128 VGND VPWR sky130_fd_sc_hd__tapvpwrvgnd_1
XFILLER_26_235 VGND VGND VPWR VPWR sky130_fd_sc_hd__decap_3
XFILLER_41_249 VGND VGND VPWR VPWR sky130_fd_sc_hd__decap_3
XTAP_TAPCELL_ROW_36_285 VGND VPWR sky130_fd_sc_hd__tapvpwrvgnd_1
XFILLER_17_257 VGND VGND VPWR VPWR sky130_fd_sc_hd__fill_2
XTAP_TAPCELL_ROW_27_241 VGND VPWR sky130_fd_sc_hd__tapvpwrvgnd_1
XFILLER_40_271 VGND VGND VPWR VPWR sky130_fd_sc_hd__decap_3
XFILLER_4_21 VGND VGND VPWR VPWR sky130_fd_sc_hd__fill_2
XFILLER_4_194 VGND VGND VPWR VPWR sky130_fd_sc_hd__fill_2
XFILLER_4_150 VGND VGND VPWR VPWR sky130_fd_sc_hd__decap_3
XFILLER_23_205 VGND VGND VPWR VPWR sky130_fd_sc_hd__decap_3
XFILLER_31_271 VGND VGND VPWR VPWR sky130_fd_sc_hd__decap_3
XFILLER_48_49 VGND VGND VPWR VPWR sky130_fd_sc_hd__decap_3
XFILLER_13_30 VGND VGND VPWR VPWR sky130_fd_sc_hd__decap_3
XFILLER_14_249 VGND VGND VPWR VPWR sky130_fd_sc_hd__decap_3
Xfanout64 fanout66/X VGND VGND VPWR VPWR wire65/A sky130_fd_sc_hd__clkdlybuf4s25_1
XFILLER_13_96 VGND VGND VPWR VPWR sky130_fd_sc_hd__decap_3
XTAP_TAPCELL_ROW_0_99 VGND VPWR sky130_fd_sc_hd__tapvpwrvgnd_1
XFILLER_20_208 VGND VGND VPWR VPWR sky130_fd_sc_hd__decap_3
X_0941_ _0941_/A _1007_/A VGND VGND VPWR VPWR _0942_/A sky130_fd_sc_hd__nand2_2
X_0872_ _0866_/A _0866_/B _0866_/C VGND VGND VPWR VPWR _0872_/Y sky130_fd_sc_hd__a21oi_4
XFILLER_9_275 VGND VGND VPWR VPWR sky130_fd_sc_hd__decap_3
XFILLER_9_231 VGND VGND VPWR VPWR sky130_fd_sc_hd__fill_2
X_1286_ _1291_/CLK input5/X wire72/X VGND VGND VPWR VPWR _1286_/Q sky130_fd_sc_hd__dfrtp_2
XFILLER_11_219 VGND VGND VPWR VPWR sky130_fd_sc_hd__decap_3
XFILLER_46_105 VGND VGND VPWR VPWR sky130_fd_sc_hd__decap_3
XFILLER_10_285 VGND VGND VPWR VPWR sky130_fd_sc_hd__fill_1
XFILLER_24_62 VGND VGND VPWR VPWR sky130_fd_sc_hd__decap_3
XFILLER_6_256 VGND VGND VPWR VPWR sky130_fd_sc_hd__decap_3
XFILLER_6_234 VGND VGND VPWR VPWR sky130_fd_sc_hd__decap_3
XFILLER_6_212 VGND VGND VPWR VPWR sky130_fd_sc_hd__fill_1
XFILLER_1_22 VGND VGND VPWR VPWR sky130_fd_sc_hd__decap_3
XFILLER_1_88 VGND VGND VPWR VPWR sky130_fd_sc_hd__fill_2
XFILLER_1_99 VGND VGND VPWR VPWR sky130_fd_sc_hd__decap_3
XFILLER_37_127 VGND VGND VPWR VPWR sky130_fd_sc_hd__decap_3
X_1140_ _1140_/A _1140_/B VGND VGND VPWR VPWR _1141_/B sky130_fd_sc_hd__nand2_2
X_1071_ _1120_/A _1071_/B _1120_/B _1120_/C VGND VGND VPWR VPWR _1071_/X sky130_fd_sc_hd__and4_2
X_0924_ _0914_/Y _0919_/Y _1004_/A VGND VGND VPWR VPWR _0929_/A sky130_fd_sc_hd__o21ai_2
X_0855_ _0854_/Y _0839_/Y _0844_/A VGND VGND VPWR VPWR _0855_/Y sky130_fd_sc_hd__a21oi_4
X_0786_ _0727_/A _0727_/B _0940_/A _1067_/A _0692_/Y VGND VGND VPWR VPWR _0787_/B
+ sky130_fd_sc_hd__a41o_2
XFILLER_28_138 VGND VGND VPWR VPWR sky130_fd_sc_hd__fill_2
XFILLER_36_182 VGND VGND VPWR VPWR sky130_fd_sc_hd__fill_1
X_1269_ clkload5/A _1269_/D wire65/X VGND VGND VPWR VPWR _1269_/Q sky130_fd_sc_hd__dfrtp_2
XTAP_TAPCELL_ROW_41_309 VGND VPWR sky130_fd_sc_hd__tapvpwrvgnd_1
XFILLER_19_51 VGND VGND VPWR VPWR sky130_fd_sc_hd__decap_3
XFILLER_19_73 VGND VGND VPWR VPWR sky130_fd_sc_hd__decap_3
X_0640_ _0689_/A VGND VGND VPWR VPWR _0642_/D sky130_fd_sc_hd__clkbuf_1
XFILLER_18_3 VGND VGND VPWR VPWR sky130_fd_sc_hd__decap_3
X_1123_ _1123_/A _1123_/B _1123_/C VGND VGND VPWR VPWR _1123_/Y sky130_fd_sc_hd__nand3_2
X_1054_ _1054_/A1 _1007_/A _1007_/B _0947_/C VGND VGND VPWR VPWR _1054_/X sky130_fd_sc_hd__a31o_2
X_0907_ _0894_/Y _0895_/Y _0896_/Y VGND VGND VPWR VPWR _0973_/B sky130_fd_sc_hd__o21ai_4
Xoutput19 _1283_/Q VGND VGND VPWR VPWR a_out[1] sky130_fd_sc_hd__clkdlybuf4s25_1
X_0838_ _0838_/A1 _0833_/Y _0829_/Y _0819_/Y VGND VGND VPWR VPWR _0885_/C sky130_fd_sc_hd__o211ai_4
X_0769_ _0723_/Y _0683_/X _0722_/Y VGND VGND VPWR VPWR _0769_/X sky130_fd_sc_hd__o21a_4
XFILLER_24_130 VGND VGND VPWR VPWR sky130_fd_sc_hd__decap_3
XFILLER_24_141 VGND VGND VPWR VPWR sky130_fd_sc_hd__decap_3
XFILLER_24_163 VGND VGND VPWR VPWR sky130_fd_sc_hd__decap_3
XFILLER_46_71 VGND VGND VPWR VPWR sky130_fd_sc_hd__decap_3
XFILLER_47_255 VGND VGND VPWR VPWR sky130_fd_sc_hd__decap_3
Xmax_cap61 _0642_/B VGND VGND VPWR VPWR _0870_/A sky130_fd_sc_hd__buf_2
XFILLER_30_177 VGND VGND VPWR VPWR sky130_fd_sc_hd__decap_3
XFILLER_7_54 VGND VGND VPWR VPWR sky130_fd_sc_hd__fill_2
XFILLER_38_200 VGND VGND VPWR VPWR sky130_fd_sc_hd__fill_2
XFILLER_38_244 VGND VGND VPWR VPWR sky130_fd_sc_hd__decap_3
XFILLER_38_277 VGND VGND VPWR VPWR sky130_fd_sc_hd__decap_3
X_1106_ _1104_/X _1106_/B VGND VGND VPWR VPWR _1108_/A sky130_fd_sc_hd__and2b_2
XFILLER_21_122 VGND VGND VPWR VPWR sky130_fd_sc_hd__decap_3
XFILLER_42_29 VGND VGND VPWR VPWR sky130_fd_sc_hd__fill_2
X_1037_ _0978_/A _0974_/C _0978_/C _0977_/X VGND VGND VPWR VPWR _1037_/Y sky130_fd_sc_hd__a31oi_2
XFILLER_21_188 VGND VGND VPWR VPWR sky130_fd_sc_hd__fill_1
XFILLER_21_199 VGND VGND VPWR VPWR sky130_fd_sc_hd__fill_1
XFILLER_44_236 VGND VGND VPWR VPWR sky130_fd_sc_hd__decap_3
XFILLER_12_122 VGND VGND VPWR VPWR sky130_fd_sc_hd__decap_3
XFILLER_12_144 VGND VGND VPWR VPWR sky130_fd_sc_hd__decap_3
XFILLER_16_85 VGND VGND VPWR VPWR sky130_fd_sc_hd__decap_3
XPHY_EDGE_ROW_11_Right_11 VGND VGND VPWR VPWR sky130_fd_sc_hd__decap_3
XFILLER_8_159 VGND VGND VPWR VPWR sky130_fd_sc_hd__decap_3
XFILLER_8_137 VGND VGND VPWR VPWR sky130_fd_sc_hd__decap_3
XFILLER_8_115 VGND VGND VPWR VPWR sky130_fd_sc_hd__decap_3
XPHY_EDGE_ROW_20_Right_20 VGND VGND VPWR VPWR sky130_fd_sc_hd__decap_3
XFILLER_35_203 VGND VGND VPWR VPWR sky130_fd_sc_hd__fill_1
XTAP_TAPCELL_ROW_13_172 VGND VPWR sky130_fd_sc_hd__tapvpwrvgnd_1
XTAP_TAPCELL_ROW_5_129 VGND VPWR sky130_fd_sc_hd__tapvpwrvgnd_1
XFILLER_26_203 VGND VGND VPWR VPWR sky130_fd_sc_hd__decap_3
XFILLER_26_247 VGND VGND VPWR VPWR sky130_fd_sc_hd__fill_1
XFILLER_41_228 VGND VGND VPWR VPWR sky130_fd_sc_hd__decap_3
XTAP_TAPCELL_ROW_36_286 VGND VPWR sky130_fd_sc_hd__tapvpwrvgnd_1
XFILLER_5_129 VGND VGND VPWR VPWR sky130_fd_sc_hd__decap_3
XFILLER_17_236 VGND VGND VPWR VPWR sky130_fd_sc_hd__decap_3
XFILLER_32_206 VGND VGND VPWR VPWR sky130_fd_sc_hd__decap_3
XTAP_TAPCELL_ROW_27_242 VGND VPWR sky130_fd_sc_hd__tapvpwrvgnd_1
XFILLER_40_250 VGND VGND VPWR VPWR sky130_fd_sc_hd__fill_2
XTAP_TAPCELL_ROW_10_153 VGND VPWR sky130_fd_sc_hd__tapvpwrvgnd_1
XFILLER_23_228 VGND VGND VPWR VPWR sky130_fd_sc_hd__fill_2
XFILLER_23_239 VGND VGND VPWR VPWR sky130_fd_sc_hd__decap_3
Xclkbuf_3_2__f_clk clkbuf_0_clk/X VGND VGND VPWR VPWR clkload1/A sky130_fd_sc_hd__clkbuf_16
XFILLER_14_206 VGND VGND VPWR VPWR sky130_fd_sc_hd__fill_1
XTAP_TAPCELL_ROW_24_223 VGND VPWR sky130_fd_sc_hd__tapvpwrvgnd_1
XTAP_TAPCELL_ROW_1_110 VGND VPWR sky130_fd_sc_hd__tapvpwrvgnd_1
XFILLER_13_42 VGND VGND VPWR VPWR sky130_fd_sc_hd__decap_3
XFILLER_38_83 VGND VGND VPWR VPWR sky130_fd_sc_hd__fill_1
XFILLER_38_94 VGND VGND VPWR VPWR sky130_fd_sc_hd__decap_3
X_0940_ _0940_/A _1001_/D VGND VGND VPWR VPWR _0945_/A sky130_fd_sc_hd__nand2_2
XFILLER_9_221 VGND VGND VPWR VPWR sky130_fd_sc_hd__decap_3
X_0871_ _0879_/A _0871_/A2 _0868_/X _0880_/C VGND VGND VPWR VPWR _0871_/X sky130_fd_sc_hd__a31o_4
XFILLER_9_254 VGND VGND VPWR VPWR sky130_fd_sc_hd__decap_3
X_1285_ _1291_/CLK input4/X fanout66/X VGND VGND VPWR VPWR _1285_/Q sky130_fd_sc_hd__dfrtp_2
XFILLER_24_74 VGND VGND VPWR VPWR sky130_fd_sc_hd__decap_3
XFILLER_24_85 VGND VGND VPWR VPWR sky130_fd_sc_hd__decap_3
XFILLER_10_220 VGND VGND VPWR VPWR sky130_fd_sc_hd__decap_3
XFILLER_6_246 VGND VGND VPWR VPWR sky130_fd_sc_hd__decap_3
XFILLER_1_34 VGND VGND VPWR VPWR sky130_fd_sc_hd__decap_3
XFILLER_37_139 VGND VGND VPWR VPWR sky130_fd_sc_hd__decap_3
XFILLER_45_183 VGND VGND VPWR VPWR sky130_fd_sc_hd__fill_2
X_1070_ _1070_/A VGND VGND VPWR VPWR _1120_/B sky130_fd_sc_hd__buf_6
X_0923_ _0923_/A _0923_/B _0923_/C VGND VGND VPWR VPWR _1004_/A sky130_fd_sc_hd__nand3_4
X_0854_ _0854_/A _0854_/B VGND VGND VPWR VPWR _0854_/Y sky130_fd_sc_hd__nand2_2
X_0785_ _0778_/A _0922_/B _0783_/Y _0784_/Y VGND VGND VPWR VPWR _0785_/Y sky130_fd_sc_hd__o211ai_2
X_1268_ clkload4/A _1268_/D wire65/X VGND VGND VPWR VPWR _1268_/Q sky130_fd_sc_hd__dfrtp_2
XFILLER_36_150 VGND VGND VPWR VPWR sky130_fd_sc_hd__fill_1
XFILLER_36_161 VGND VGND VPWR VPWR sky130_fd_sc_hd__decap_3
X_1199_ _1199_/A _1199_/B VGND VGND VPWR VPWR _1200_/B sky130_fd_sc_hd__nand2_2
XFILLER_3_205 VGND VGND VPWR VPWR sky130_fd_sc_hd__decap_3
XFILLER_3_249 VGND VGND VPWR VPWR sky130_fd_sc_hd__fill_2
XFILLER_19_128 VGND VGND VPWR VPWR sky130_fd_sc_hd__fill_2
XFILLER_35_40 VGND VGND VPWR VPWR sky130_fd_sc_hd__decap_3
XFILLER_42_164 VGND VGND VPWR VPWR sky130_fd_sc_hd__decap_3
XFILLER_42_197 VGND VGND VPWR VPWR sky130_fd_sc_hd__fill_2
XPHY_EDGE_ROW_27_Left_76 VGND VGND VPWR VPWR sky130_fd_sc_hd__decap_3
XFILLER_32_6 VGND VGND VPWR VPWR sky130_fd_sc_hd__decap_3
X_1122_ _1103_/B _1120_/B _1119_/A _1120_/X VGND VGND VPWR VPWR _1123_/A sky130_fd_sc_hd__a31o_2
XFILLER_18_150 VGND VGND VPWR VPWR sky130_fd_sc_hd__decap_3
XFILLER_18_183 VGND VGND VPWR VPWR sky130_fd_sc_hd__fill_1
X_1053_ _1010_/A _1007_/A _1007_/B VGND VGND VPWR VPWR _1053_/Y sky130_fd_sc_hd__a21oi_2
X_0906_ _0759_/A _0822_/Y _0900_/Y _0901_/Y VGND VGND VPWR VPWR _0906_/X sky130_fd_sc_hd__o211a_4
X_0837_ _0922_/A _0903_/A VGND VGND VPWR VPWR _0885_/B sky130_fd_sc_hd__nor2_2
X_0768_ _0768_/A VGND VGND VPWR VPWR _0768_/Y sky130_fd_sc_hd__inv_4
X_0699_ _0699_/A _0699_/B VGND VGND VPWR VPWR _0699_/Y sky130_fd_sc_hd__nor2_2
XFILLER_24_197 VGND VGND VPWR VPWR sky130_fd_sc_hd__decap_3
XFILLER_47_212 VGND VGND VPWR VPWR sky130_fd_sc_hd__decap_3
XFILLER_47_234 VGND VGND VPWR VPWR sky130_fd_sc_hd__decap_3
XFILLER_15_131 VGND VGND VPWR VPWR sky130_fd_sc_hd__decap_3
XFILLER_15_186 VGND VGND VPWR VPWR sky130_fd_sc_hd__fill_2
XFILLER_47_267 VGND VGND VPWR VPWR sky130_fd_sc_hd__decap_3
Xmax_cap62 _1147_/X VGND VGND VPWR VPWR _1182_/A sky130_fd_sc_hd__buf_2
XFILLER_30_167 VGND VGND VPWR VPWR sky130_fd_sc_hd__decap_3
XFILLER_7_33 VGND VGND VPWR VPWR sky130_fd_sc_hd__decap_3
XFILLER_30_3 VGND VGND VPWR VPWR sky130_fd_sc_hd__decap_3
XFILLER_38_256 VGND VGND VPWR VPWR sky130_fd_sc_hd__decap_3
X_1105_ _1102_/Y _1103_/X _1104_/C _1119_/C VGND VGND VPWR VPWR _1106_/B sky130_fd_sc_hd__a2bb2o_2
X_1036_ _1036_/A _1036_/B _1081_/C _1036_/D VGND VGND VPWR VPWR _1083_/A sky130_fd_sc_hd__nand4_2
XFILLER_29_201 VGND VGND VPWR VPWR sky130_fd_sc_hd__decap_3
XFILLER_44_248 VGND VGND VPWR VPWR sky130_fd_sc_hd__decap_3
XFILLER_44_259 VGND VGND VPWR VPWR sky130_fd_sc_hd__decap_3
XFILLER_12_178 VGND VGND VPWR VPWR sky130_fd_sc_hd__decap_3
XFILLER_32_63 VGND VGND VPWR VPWR sky130_fd_sc_hd__decap_3
XFILLER_32_85 VGND VGND VPWR VPWR sky130_fd_sc_hd__decap_3
XFILLER_35_237 VGND VGND VPWR VPWR sky130_fd_sc_hd__fill_2
XFILLER_43_270 VGND VGND VPWR VPWR sky130_fd_sc_hd__decap_3
XFILLER_43_281 VGND VGND VPWR VPWR sky130_fd_sc_hd__decap_3
XFILLER_7_193 VGND VGND VPWR VPWR sky130_fd_sc_hd__decap_3
XFILLER_26_215 VGND VGND VPWR VPWR sky130_fd_sc_hd__decap_3
X_1019_ _0987_/A _0987_/D _0976_/Y VGND VGND VPWR VPWR _1082_/B sky130_fd_sc_hd__a21o_2
XPHY_EDGE_ROW_14_Left_63 VGND VGND VPWR VPWR sky130_fd_sc_hd__decap_3
XTAP_TAPCELL_ROW_36_287 VGND VPWR sky130_fd_sc_hd__tapvpwrvgnd_1
XFILLER_5_108 VGND VGND VPWR VPWR sky130_fd_sc_hd__decap_3
XFILLER_17_248 VGND VGND VPWR VPWR sky130_fd_sc_hd__decap_3
XFILLER_25_281 VGND VGND VPWR VPWR sky130_fd_sc_hd__decap_3
XFILLER_27_74 VGND VGND VPWR VPWR sky130_fd_sc_hd__decap_3
XFILLER_40_262 VGND VGND VPWR VPWR sky130_fd_sc_hd__decap_3
XFILLER_43_84 VGND VGND VPWR VPWR sky130_fd_sc_hd__fill_2
XTAP_TAPCELL_ROW_10_154 VGND VPWR sky130_fd_sc_hd__tapvpwrvgnd_1
XFILLER_4_141 VGND VGND VPWR VPWR sky130_fd_sc_hd__decap_3
XFILLER_4_185 VGND VGND VPWR VPWR sky130_fd_sc_hd__decap_3
XFILLER_4_12 VGND VGND VPWR VPWR sky130_fd_sc_hd__decap_3
XFILLER_31_240 VGND VGND VPWR VPWR sky130_fd_sc_hd__fill_2
XFILLER_31_284 VGND VGND VPWR VPWR sky130_fd_sc_hd__fill_2
XTAP_TAPCELL_ROW_33_268 VGND VPWR sky130_fd_sc_hd__tapvpwrvgnd_1
XTAP_TAPCELL_ROW_1_111 VGND VPWR sky130_fd_sc_hd__tapvpwrvgnd_1
XFILLER_22_251 VGND VGND VPWR VPWR sky130_fd_sc_hd__fill_1
XTAP_TAPCELL_ROW_24_224 VGND VPWR sky130_fd_sc_hd__tapvpwrvgnd_1
XFILLER_13_21 VGND VGND VPWR VPWR sky130_fd_sc_hd__decap_3
XFILLER_13_87 VGND VGND VPWR VPWR sky130_fd_sc_hd__decap_3
Xfanout66 fanout73/X VGND VGND VPWR VPWR fanout66/X sky130_fd_sc_hd__clkdlybuf4s25_1
XFILLER_1_111 VGND VGND VPWR VPWR sky130_fd_sc_hd__fill_1
XFILLER_1_122 VGND VGND VPWR VPWR sky130_fd_sc_hd__decap_3
XFILLER_38_62 VGND VGND VPWR VPWR sky130_fd_sc_hd__decap_3
XTAP_TAPCELL_ROW_47_338 VGND VPWR sky130_fd_sc_hd__tapvpwrvgnd_1
XFILLER_13_251 VGND VGND VPWR VPWR sky130_fd_sc_hd__decap_3
XFILLER_13_284 VGND VGND VPWR VPWR sky130_fd_sc_hd__fill_2
X_0870_ _0870_/A _1001_/D VGND VGND VPWR VPWR _0880_/C sky130_fd_sc_hd__and2_2
XFILLER_9_266 VGND VGND VPWR VPWR sky130_fd_sc_hd__decap_3
X_1284_ clkload4/A input3/X fanout66/X VGND VGND VPWR VPWR _1284_/Q sky130_fd_sc_hd__dfrtp_2
XFILLER_48_192 VGND VGND VPWR VPWR sky130_fd_sc_hd__decap_3
XFILLER_48_181 VGND VGND VPWR VPWR sky130_fd_sc_hd__decap_3
X_0999_ _1004_/A _1004_/D VGND VGND VPWR VPWR _1003_/B sky130_fd_sc_hd__nand2_2
XFILLER_10_232 VGND VGND VPWR VPWR sky130_fd_sc_hd__decap_3
XFILLER_24_53 VGND VGND VPWR VPWR sky130_fd_sc_hd__decap_3
XFILLER_24_97 VGND VGND VPWR VPWR sky130_fd_sc_hd__decap_3
XFILLER_10_276 VGND VGND VPWR VPWR sky130_fd_sc_hd__decap_3
XFILLER_40_85 VGND VGND VPWR VPWR sky130_fd_sc_hd__decap_3
XFILLER_6_203 VGND VGND VPWR VPWR sky130_fd_sc_hd__decap_3
XFILLER_1_46 VGND VGND VPWR VPWR sky130_fd_sc_hd__fill_1
XFILLER_1_57 VGND VGND VPWR VPWR sky130_fd_sc_hd__decap_3
XFILLER_1_79 VGND VGND VPWR VPWR sky130_fd_sc_hd__decap_3
X_0922_ _0922_/A _0922_/B VGND VGND VPWR VPWR _0923_/C sky130_fd_sc_hd__nor2_2
X_0853_ _0819_/Y _0826_/Y _0836_/A VGND VGND VPWR VPWR _0854_/B sky130_fd_sc_hd__a21o_2
X_0784_ _0783_/A _0783_/B _0769_/X _0768_/Y VGND VGND VPWR VPWR _0784_/Y sky130_fd_sc_hd__o2bb2ai_2
X_1198_ _1193_/X _1196_/Y _1197_/X VGND VGND VPWR VPWR _1198_/Y sky130_fd_sc_hd__a21oi_2
X_1267_ _1291_/CLK _1267_/D wire65/X VGND VGND VPWR VPWR _1267_/Q sky130_fd_sc_hd__dfrtp_2
Xinput1 a_in[0] VGND VGND VPWR VPWR input1/X sky130_fd_sc_hd__clkdlybuf4s25_1
XFILLER_36_173 VGND VGND VPWR VPWR sky130_fd_sc_hd__decap_3
XFILLER_3_228 VGND VGND VPWR VPWR sky130_fd_sc_hd__decap_3
XFILLER_19_42 VGND VGND VPWR VPWR sky130_fd_sc_hd__decap_3
XFILLER_19_64 VGND VGND VPWR VPWR sky130_fd_sc_hd__decap_3
XFILLER_19_86 VGND VGND VPWR VPWR sky130_fd_sc_hd__decap_3
XFILLER_35_63 VGND VGND VPWR VPWR sky130_fd_sc_hd__fill_1
XFILLER_42_176 VGND VGND VPWR VPWR sky130_fd_sc_hd__fill_1
XPHY_EDGE_ROW_2_Left_51 VGND VGND VPWR VPWR sky130_fd_sc_hd__decap_3
XFILLER_25_6 VGND VGND VPWR VPWR sky130_fd_sc_hd__decap_3
X_1121_ _1123_/B _1123_/C _1103_/B _1103_/C _1120_/X VGND VGND VPWR VPWR _1121_/X
+ sky130_fd_sc_hd__a221o_2
X_1052_ _0880_/A _0880_/B _0880_/C VGND VGND VPWR VPWR _1052_/Y sky130_fd_sc_hd__a21oi_2
XFILLER_18_162 VGND VGND VPWR VPWR sky130_fd_sc_hd__decap_3
XFILLER_18_195 VGND VGND VPWR VPWR sky130_fd_sc_hd__fill_1
XFILLER_33_187 VGND VGND VPWR VPWR sky130_fd_sc_hd__fill_1
X_0905_ _0900_/Y _0901_/Y _0892_/Y VGND VGND VPWR VPWR _0905_/Y sky130_fd_sc_hd__a21oi_4
X_0836_ _0836_/A _0836_/B VGND VGND VPWR VPWR _0885_/A sky130_fd_sc_hd__nand2_4
X_0767_ _0783_/A VGND VGND VPWR VPWR _0767_/Y sky130_fd_sc_hd__inv_2
X_0698_ _0870_/A _1067_/A _0697_/X VGND VGND VPWR VPWR _0699_/B sky130_fd_sc_hd__a21oi_2
XPHY_EDGE_ROW_44_Left_93 VGND VGND VPWR VPWR sky130_fd_sc_hd__decap_3
XFILLER_21_54 VGND VGND VPWR VPWR sky130_fd_sc_hd__fill_2
XFILLER_21_76 VGND VGND VPWR VPWR sky130_fd_sc_hd__fill_2
XFILLER_47_246 VGND VGND VPWR VPWR sky130_fd_sc_hd__decap_3
XFILLER_47_279 VGND VGND VPWR VPWR sky130_fd_sc_hd__fill_1
XFILLER_15_110 VGND VGND VPWR VPWR sky130_fd_sc_hd__fill_2
XFILLER_15_165 VGND VGND VPWR VPWR sky130_fd_sc_hd__decap_3
XFILLER_30_135 VGND VGND VPWR VPWR sky130_fd_sc_hd__decap_3
XFILLER_46_62 VGND VGND VPWR VPWR sky130_fd_sc_hd__decap_3
Xmax_cap63 _0799_/A VGND VGND VPWR VPWR _1191_/A sky130_fd_sc_hd__buf_2
XFILLER_7_45 VGND VGND VPWR VPWR sky130_fd_sc_hd__decap_3
XFILLER_23_3 VGND VGND VPWR VPWR sky130_fd_sc_hd__decap_3
XFILLER_38_213 VGND VGND VPWR VPWR sky130_fd_sc_hd__decap_3
XFILLER_38_235 VGND VGND VPWR VPWR sky130_fd_sc_hd__decap_3
XFILLER_38_268 VGND VGND VPWR VPWR sky130_fd_sc_hd__decap_3
X_1104_ _1102_/Y _1103_/X _1104_/C _1297_/Q VGND VGND VPWR VPWR _1104_/X sky130_fd_sc_hd__and4bb_2
X_1035_ _1035_/A _1035_/B _1038_/A _1038_/B VGND VGND VPWR VPWR _1036_/B sky130_fd_sc_hd__nand4_2
XFILLER_21_102 VGND VGND VPWR VPWR sky130_fd_sc_hd__fill_2
XFILLER_21_113 VGND VGND VPWR VPWR sky130_fd_sc_hd__decap_3
X_0819_ _0819_/A _0819_/B VGND VGND VPWR VPWR _0819_/Y sky130_fd_sc_hd__nand2_4
XFILLER_29_213 VGND VGND VPWR VPWR sky130_fd_sc_hd__decap_3
XFILLER_29_279 VGND VGND VPWR VPWR sky130_fd_sc_hd__fill_1
XFILLER_16_32 VGND VGND VPWR VPWR sky130_fd_sc_hd__decap_3
XFILLER_44_227 VGND VGND VPWR VPWR sky130_fd_sc_hd__decap_3
XFILLER_32_97 VGND VGND VPWR VPWR sky130_fd_sc_hd__decap_3
XFILLER_8_106 VGND VGND VPWR VPWR sky130_fd_sc_hd__decap_3
XPHY_EDGE_ROW_9_Right_9 VGND VGND VPWR VPWR sky130_fd_sc_hd__decap_3
XFILLER_7_161 VGND VGND VPWR VPWR sky130_fd_sc_hd__decap_3
XFILLER_26_238 VGND VGND VPWR VPWR sky130_fd_sc_hd__decap_3
X_1018_ _1018_/A _1018_/B VGND VGND VPWR VPWR _1063_/B sky130_fd_sc_hd__nand2_2
XFILLER_40_241 VGND VGND VPWR VPWR sky130_fd_sc_hd__decap_3
XFILLER_40_274 VGND VGND VPWR VPWR sky130_fd_sc_hd__decap_3
XFILLER_43_41 VGND VGND VPWR VPWR sky130_fd_sc_hd__decap_3
XTAP_TAPCELL_ROW_10_155 VGND VPWR sky130_fd_sc_hd__tapvpwrvgnd_1
XFILLER_4_153 VGND VGND VPWR VPWR sky130_fd_sc_hd__decap_3
XPHY_EDGE_ROW_31_Left_80 VGND VGND VPWR VPWR sky130_fd_sc_hd__decap_3
XFILLER_23_208 VGND VGND VPWR VPWR sky130_fd_sc_hd__decap_3
XFILLER_31_274 VGND VGND VPWR VPWR sky130_fd_sc_hd__decap_3
XTAP_TAPCELL_ROW_33_269 VGND VPWR sky130_fd_sc_hd__tapvpwrvgnd_1
XFILLER_48_19 VGND VGND VPWR VPWR sky130_fd_sc_hd__decap_3
XTAP_TAPCELL_ROW_1_112 VGND VPWR sky130_fd_sc_hd__tapvpwrvgnd_1
XFILLER_13_33 VGND VGND VPWR VPWR sky130_fd_sc_hd__decap_3
XFILLER_22_230 VGND VGND VPWR VPWR sky130_fd_sc_hd__decap_3
Xfanout67 fanout70/X VGND VGND VPWR VPWR wire68/A sky130_fd_sc_hd__clkdlybuf4s25_1
XTAP_TAPCELL_ROW_24_225 VGND VPWR sky130_fd_sc_hd__tapvpwrvgnd_1
XFILLER_13_99 VGND VGND VPWR VPWR sky130_fd_sc_hd__fill_1
XFILLER_1_167 VGND VGND VPWR VPWR sky130_fd_sc_hd__fill_1
XFILLER_38_85 VGND VGND VPWR VPWR sky130_fd_sc_hd__decap_3
XTAP_TAPCELL_ROW_47_339 VGND VPWR sky130_fd_sc_hd__tapvpwrvgnd_1
XFILLER_9_278 VGND VGND VPWR VPWR sky130_fd_sc_hd__fill_2
XFILLER_9_212 VGND VGND VPWR VPWR sky130_fd_sc_hd__decap_3
X_1283_ clkload4/A input2/X wire65/X VGND VGND VPWR VPWR _1283_/Q sky130_fd_sc_hd__dfrtp_2
X_0998_ _0998_/A1 _0919_/Y _0998_/B1 VGND VGND VPWR VPWR _1004_/D sky130_fd_sc_hd__o21ai_2
XFILLER_46_108 VGND VGND VPWR VPWR sky130_fd_sc_hd__fill_2
XFILLER_10_200 VGND VGND VPWR VPWR sky130_fd_sc_hd__decap_3
XFILLER_24_21 VGND VGND VPWR VPWR sky130_fd_sc_hd__decap_3
XFILLER_24_32 VGND VGND VPWR VPWR sky130_fd_sc_hd__decap_3
XFILLER_24_65 VGND VGND VPWR VPWR sky130_fd_sc_hd__decap_3
XFILLER_6_259 VGND VGND VPWR VPWR sky130_fd_sc_hd__fill_1
XFILLER_6_237 VGND VGND VPWR VPWR sky130_fd_sc_hd__decap_3
XFILLER_1_25 VGND VGND VPWR VPWR sky130_fd_sc_hd__decap_3
X_0921_ _0990_/A _0921_/B _0990_/B VGND VGND VPWR VPWR _0923_/A sky130_fd_sc_hd__nand3_2
XTAP_TAPCELL_ROW_43_320 VGND VPWR sky130_fd_sc_hd__tapvpwrvgnd_1
X_0852_ _0819_/Y _0826_/Y _0836_/A _0885_/B VGND VGND VPWR VPWR _0854_/A sky130_fd_sc_hd__a31oi_4
X_0783_ _0783_/A _0783_/B _0783_/C VGND VGND VPWR VPWR _0783_/Y sky130_fd_sc_hd__nand3_2
XFILLER_5_281 VGND VGND VPWR VPWR sky130_fd_sc_hd__decap_3
XFILLER_28_119 VGND VGND VPWR VPWR sky130_fd_sc_hd__decap_3
XFILLER_36_141 VGND VGND VPWR VPWR sky130_fd_sc_hd__decap_3
X_1197_ _1258_/Q _1276_/Q _1200_/C VGND VGND VPWR VPWR _1197_/X sky130_fd_sc_hd__and3_2
X_1266_ _1291_/CLK _1266_/D wire65/X VGND VGND VPWR VPWR _1266_/Q sky130_fd_sc_hd__dfrtp_2
Xinput2 a_in[1] VGND VGND VPWR VPWR input2/X sky130_fd_sc_hd__clkdlybuf4s25_1
XFILLER_19_21 VGND VGND VPWR VPWR sky130_fd_sc_hd__decap_3
XFILLER_19_54 VGND VGND VPWR VPWR sky130_fd_sc_hd__fill_2
XFILLER_19_76 VGND VGND VPWR VPWR sky130_fd_sc_hd__fill_1
XFILLER_19_98 VGND VGND VPWR VPWR sky130_fd_sc_hd__decap_3
XFILLER_27_152 VGND VGND VPWR VPWR sky130_fd_sc_hd__decap_3
XFILLER_27_163 VGND VGND VPWR VPWR sky130_fd_sc_hd__decap_3
XFILLER_35_53 VGND VGND VPWR VPWR sky130_fd_sc_hd__decap_3
XFILLER_42_155 VGND VGND VPWR VPWR sky130_fd_sc_hd__decap_3
XFILLER_18_130 VGND VGND VPWR VPWR sky130_fd_sc_hd__decap_3
XFILLER_18_141 VGND VGND VPWR VPWR sky130_fd_sc_hd__decap_3
XFILLER_18_174 VGND VGND VPWR VPWR sky130_fd_sc_hd__decap_3
XFILLER_18_6 VGND VGND VPWR VPWR sky130_fd_sc_hd__decap_3
X_1120_ _1120_/A _1120_/B _1120_/C VGND VGND VPWR VPWR _1120_/X sky130_fd_sc_hd__and3_2
X_1051_ _1063_/A _1063_/B _1064_/A _1064_/B VGND VGND VPWR VPWR _1093_/C sky130_fd_sc_hd__and4_4
XFILLER_33_122 VGND VGND VPWR VPWR sky130_fd_sc_hd__decap_3
X_0904_ _0978_/A _0897_/X _0973_/A _0912_/B VGND VGND VPWR VPWR _0909_/B sky130_fd_sc_hd__a31oi_2
X_0835_ _0922_/A _0903_/A _0829_/Y _0836_/B VGND VGND VPWR VPWR _0835_/Y sky130_fd_sc_hd__o22ai_4
X_0766_ _0766_/A _0766_/B _0766_/C VGND VGND VPWR VPWR _0783_/A sky130_fd_sc_hd__nand3_4
X_0697_ _0697_/A _0697_/B VGND VGND VPWR VPWR _0697_/X sky130_fd_sc_hd__or2_2
XFILLER_24_133 VGND VGND VPWR VPWR sky130_fd_sc_hd__decap_3
XFILLER_24_144 VGND VGND VPWR VPWR sky130_fd_sc_hd__decap_3
XFILLER_24_166 VGND VGND VPWR VPWR sky130_fd_sc_hd__decap_3
X_1249_ _1303_/Q wire55/X _1255_/A2 _1248_/Y VGND VGND VPWR VPWR _1303_/D sky130_fd_sc_hd__a22o_2
XFILLER_21_99 VGND VGND VPWR VPWR sky130_fd_sc_hd__decap_3
XFILLER_46_74 VGND VGND VPWR VPWR sky130_fd_sc_hd__fill_1
XFILLER_46_85 VGND VGND VPWR VPWR sky130_fd_sc_hd__decap_3
XFILLER_47_225 VGND VGND VPWR VPWR sky130_fd_sc_hd__decap_3
XFILLER_47_258 VGND VGND VPWR VPWR sky130_fd_sc_hd__decap_3
Xmax_cap53 wire52/A VGND VGND VPWR VPWR _0991_/D sky130_fd_sc_hd__buf_6
XFILLER_15_122 VGND VGND VPWR VPWR sky130_fd_sc_hd__decap_3
XFILLER_30_158 VGND VGND VPWR VPWR sky130_fd_sc_hd__decap_3
XFILLER_7_57 VGND VGND VPWR VPWR sky130_fd_sc_hd__fill_1
XFILLER_7_24 VGND VGND VPWR VPWR sky130_fd_sc_hd__decap_3
XFILLER_16_3 VGND VGND VPWR VPWR sky130_fd_sc_hd__decap_3
XFILLER_38_247 VGND VGND VPWR VPWR sky130_fd_sc_hd__decap_3
X_1103_ _1103_/A _1103_/B _1103_/C VGND VGND VPWR VPWR _1103_/X sky130_fd_sc_hd__and3_2
X_1034_ _1035_/A _1035_/B _1038_/A _1038_/B VGND VGND VPWR VPWR _1036_/A sky130_fd_sc_hd__a22o_2
XFILLER_21_125 VGND VGND VPWR VPWR sky130_fd_sc_hd__fill_1
XFILLER_21_169 VGND VGND VPWR VPWR sky130_fd_sc_hd__decap_3
XTAP_TAPCELL_ROW_16_183 VGND VPWR sky130_fd_sc_hd__tapvpwrvgnd_1
X_0818_ _0813_/Y _0817_/X _0746_/Y VGND VGND VPWR VPWR _0819_/B sky130_fd_sc_hd__o21ai_4
X_0749_ _0958_/A _0820_/A VGND VGND VPWR VPWR _0749_/X sky130_fd_sc_hd__and2_2
XFILLER_29_258 VGND VGND VPWR VPWR sky130_fd_sc_hd__decap_3
XFILLER_12_125 VGND VGND VPWR VPWR sky130_fd_sc_hd__decap_3
XFILLER_12_147 VGND VGND VPWR VPWR sky130_fd_sc_hd__decap_3
XFILLER_16_88 VGND VGND VPWR VPWR sky130_fd_sc_hd__decap_3
XFILLER_44_239 VGND VGND VPWR VPWR sky130_fd_sc_hd__decap_3
XFILLER_8_118 VGND VGND VPWR VPWR sky130_fd_sc_hd__decap_3
XTAP_TAPCELL_ROW_7_140 VGND VPWR sky130_fd_sc_hd__tapvpwrvgnd_1
XFILLER_43_261 VGND VGND VPWR VPWR sky130_fd_sc_hd__decap_3
XFILLER_26_206 VGND VGND VPWR VPWR sky130_fd_sc_hd__decap_3
X_1017_ _0949_/Y _0956_/Y _0948_/A VGND VGND VPWR VPWR _1017_/X sky130_fd_sc_hd__o21a_2
XFILLER_17_239 VGND VGND VPWR VPWR sky130_fd_sc_hd__decap_3
XFILLER_27_43 VGND VGND VPWR VPWR sky130_fd_sc_hd__decap_3
XFILLER_25_272 VGND VGND VPWR VPWR sky130_fd_sc_hd__decap_3
XFILLER_40_220 VGND VGND VPWR VPWR sky130_fd_sc_hd__fill_1
XFILLER_40_253 VGND VGND VPWR VPWR sky130_fd_sc_hd__decap_3
XTAP_TAPCELL_ROW_10_156 VGND VPWR sky130_fd_sc_hd__tapvpwrvgnd_1
XFILLER_31_231 VGND VGND VPWR VPWR sky130_fd_sc_hd__decap_3
XFILLER_13_12 VGND VGND VPWR VPWR sky130_fd_sc_hd__decap_3
XFILLER_13_45 VGND VGND VPWR VPWR sky130_fd_sc_hd__decap_3
XFILLER_22_242 VGND VGND VPWR VPWR sky130_fd_sc_hd__decap_3
XFILLER_22_253 VGND VGND VPWR VPWR sky130_fd_sc_hd__decap_3
XTAP_TAPCELL_ROW_24_226 VGND VPWR sky130_fd_sc_hd__tapvpwrvgnd_1
XFILLER_13_78 VGND VGND VPWR VPWR sky130_fd_sc_hd__fill_2
XFILLER_1_102 VGND VGND VPWR VPWR sky130_fd_sc_hd__decap_3
XFILLER_1_113 VGND VGND VPWR VPWR sky130_fd_sc_hd__decap_3
XFILLER_38_97 VGND VGND VPWR VPWR sky130_fd_sc_hd__decap_3
XFILLER_9_257 VGND VGND VPWR VPWR sky130_fd_sc_hd__decap_3
XFILLER_48_150 VGND VGND VPWR VPWR sky130_fd_sc_hd__decap_3
X_1282_ clkload4/A input1/X wire65/X VGND VGND VPWR VPWR _1282_/Q sky130_fd_sc_hd__dfrtp_2
XFILLER_48_172 VGND VGND VPWR VPWR sky130_fd_sc_hd__decap_3
X_0997_ _1003_/A _1047_/B VGND VGND VPWR VPWR _1001_/A sky130_fd_sc_hd__nand2_2
XFILLER_5_90 VGND VGND VPWR VPWR sky130_fd_sc_hd__decap_3
XFILLER_10_223 VGND VGND VPWR VPWR sky130_fd_sc_hd__decap_3
XFILLER_24_44 VGND VGND VPWR VPWR sky130_fd_sc_hd__decap_3
XFILLER_24_77 VGND VGND VPWR VPWR sky130_fd_sc_hd__decap_3
XFILLER_24_88 VGND VGND VPWR VPWR sky130_fd_sc_hd__decap_3
XFILLER_6_249 VGND VGND VPWR VPWR sky130_fd_sc_hd__decap_3
XFILLER_1_37 VGND VGND VPWR VPWR sky130_fd_sc_hd__decap_3
X_0920_ _0990_/B _0921_/B _0917_/Y _0916_/Y VGND VGND VPWR VPWR _0923_/B sky130_fd_sc_hd__o2bb2ai_4
XTAP_TAPCELL_ROW_43_321 VGND VPWR sky130_fd_sc_hd__tapvpwrvgnd_1
X_0851_ _0767_/Y _0803_/Y _0847_/Y _0850_/Y VGND VGND VPWR VPWR _0873_/B sky130_fd_sc_hd__a2bb2oi_4
X_0782_ _0767_/Y _0803_/A _0792_/B _0781_/Y VGND VGND VPWR VPWR _0782_/Y sky130_fd_sc_hd__o211ai_2
X_1265_ clkload1/A _1265_/D fanout69/X VGND VGND VPWR VPWR _1265_/Q sky130_fd_sc_hd__dfrtp_2
XPHY_EDGE_ROW_18_Right_18 VGND VGND VPWR VPWR sky130_fd_sc_hd__decap_3
XFILLER_36_164 VGND VGND VPWR VPWR sky130_fd_sc_hd__decap_3
X_1196_ _1258_/Q _1276_/Q _1200_/C VGND VGND VPWR VPWR _1196_/Y sky130_fd_sc_hd__a21oi_2
Xinput3 a_in[2] VGND VGND VPWR VPWR input3/X sky130_fd_sc_hd__clkdlybuf4s25_1
XPHY_EDGE_ROW_27_Right_27 VGND VGND VPWR VPWR sky130_fd_sc_hd__decap_3
XFILLER_3_208 VGND VGND VPWR VPWR sky130_fd_sc_hd__decap_3
XPHY_EDGE_ROW_36_Right_36 VGND VGND VPWR VPWR sky130_fd_sc_hd__decap_3
XFILLER_35_21 VGND VGND VPWR VPWR sky130_fd_sc_hd__decap_3
XFILLER_35_43 VGND VGND VPWR VPWR sky130_fd_sc_hd__fill_2
XFILLER_42_167 VGND VGND VPWR VPWR sky130_fd_sc_hd__decap_3
XPHY_EDGE_ROW_45_Right_45 VGND VGND VPWR VPWR sky130_fd_sc_hd__decap_3
XFILLER_18_153 VGND VGND VPWR VPWR sky130_fd_sc_hd__decap_3
XFILLER_18_197 VGND VGND VPWR VPWR sky130_fd_sc_hd__decap_3
XFILLER_33_101 VGND VGND VPWR VPWR sky130_fd_sc_hd__decap_3
X_1050_ _1063_/A _1063_/B _1064_/A _1064_/B VGND VGND VPWR VPWR _1093_/A sky130_fd_sc_hd__a22oi_2
X_0903_ _0903_/A _0903_/B VGND VGND VPWR VPWR _0912_/B sky130_fd_sc_hd__nor2_2
X_0834_ _0830_/Y _0831_/Y _0833_/Y _0832_/Y VGND VGND VPWR VPWR _0836_/B sky130_fd_sc_hd__o22ai_4
X_0765_ _0765_/A _0765_/B _0771_/A _0771_/B VGND VGND VPWR VPWR _0766_/C sky130_fd_sc_hd__nand4_2
X_0696_ _0697_/A _0697_/B _0870_/A _1067_/A VGND VGND VPWR VPWR _0699_/A sky130_fd_sc_hd__o211a_2
X_1248_ _1250_/C _1248_/B VGND VGND VPWR VPWR _1248_/Y sky130_fd_sc_hd__nor2_2
X_1179_ _1256_/Q _1274_/Q _1174_/Y VGND VGND VPWR VPWR _1180_/B sky130_fd_sc_hd__a21bo_2
XFILLER_47_215 VGND VGND VPWR VPWR sky130_fd_sc_hd__decap_3
XFILLER_47_237 VGND VGND VPWR VPWR sky130_fd_sc_hd__decap_3
Xmax_cap54 _1191_/Y VGND VGND VPWR VPWR _1255_/A2 sky130_fd_sc_hd__buf_2
XFILLER_15_156 VGND VGND VPWR VPWR sky130_fd_sc_hd__decap_3
XFILLER_30_126 VGND VGND VPWR VPWR sky130_fd_sc_hd__decap_3
XFILLER_7_36 VGND VGND VPWR VPWR sky130_fd_sc_hd__decap_3
XFILLER_30_6 VGND VGND VPWR VPWR sky130_fd_sc_hd__decap_3
XFILLER_38_259 VGND VGND VPWR VPWR sky130_fd_sc_hd__decap_3
X_1102_ _1103_/A _1103_/B _1103_/C VGND VGND VPWR VPWR _1102_/Y sky130_fd_sc_hd__a21oi_2
X_1033_ _1075_/A _1075_/B _1120_/C _1104_/C VGND VGND VPWR VPWR _1038_/B sky130_fd_sc_hd__nand4_2
X_0817_ _0888_/A _0890_/A _0812_/X _0810_/Y VGND VGND VPWR VPWR _0817_/X sky130_fd_sc_hd__o211a_2
XTAP_TAPCELL_ROW_16_184 VGND VPWR sky130_fd_sc_hd__tapvpwrvgnd_1
X_0748_ _0816_/A _0961_/C VGND VGND VPWR VPWR _0810_/B sky130_fd_sc_hd__nand2_4
X_0679_ _1024_/A _0820_/A VGND VGND VPWR VPWR _0680_/B sky130_fd_sc_hd__nand2_2
XFILLER_29_204 VGND VGND VPWR VPWR sky130_fd_sc_hd__decap_3
XFILLER_29_237 VGND VGND VPWR VPWR sky130_fd_sc_hd__decap_3
XFILLER_37_281 VGND VGND VPWR VPWR sky130_fd_sc_hd__decap_3
XTAP_TAPCELL_ROW_39_298 VGND VPWR sky130_fd_sc_hd__tapvpwrvgnd_1
XPHY_EDGE_ROW_0_Right_0 VGND VGND VPWR VPWR sky130_fd_sc_hd__decap_3
XFILLER_32_66 VGND VGND VPWR VPWR sky130_fd_sc_hd__fill_1
XFILLER_32_88 VGND VGND VPWR VPWR sky130_fd_sc_hd__fill_1
XTAP_TAPCELL_ROW_7_141 VGND VPWR sky130_fd_sc_hd__tapvpwrvgnd_1
XFILLER_43_240 VGND VGND VPWR VPWR sky130_fd_sc_hd__decap_3
XFILLER_43_273 VGND VGND VPWR VPWR sky130_fd_sc_hd__decap_3
XFILLER_43_284 VGND VGND VPWR VPWR sky130_fd_sc_hd__fill_2
XFILLER_11_181 VGND VGND VPWR VPWR sky130_fd_sc_hd__fill_2
XFILLER_7_196 VGND VGND VPWR VPWR sky130_fd_sc_hd__decap_3
XFILLER_19_281 VGND VGND VPWR VPWR sky130_fd_sc_hd__decap_3
XFILLER_34_240 VGND VGND VPWR VPWR sky130_fd_sc_hd__decap_3
X_1016_ _0955_/X _1013_/X _1014_/X _1117_/A _1015_/X VGND VGND VPWR VPWR _1275_/D
+ sky130_fd_sc_hd__a311oi_2
XFILLER_25_284 VGND VGND VPWR VPWR sky130_fd_sc_hd__fill_2
XFILLER_27_77 VGND VGND VPWR VPWR sky130_fd_sc_hd__decap_3
XFILLER_43_21 VGND VGND VPWR VPWR sky130_fd_sc_hd__fill_1
XFILLER_40_265 VGND VGND VPWR VPWR sky130_fd_sc_hd__decap_3
XTAP_TAPCELL_ROW_10_157 VGND VPWR sky130_fd_sc_hd__tapvpwrvgnd_1
XFILLER_4_188 VGND VGND VPWR VPWR sky130_fd_sc_hd__decap_3
XFILLER_4_15 VGND VGND VPWR VPWR sky130_fd_sc_hd__decap_3
XFILLER_4_144 VGND VGND VPWR VPWR sky130_fd_sc_hd__decap_3
XFILLER_4_100 VGND VGND VPWR VPWR sky130_fd_sc_hd__fill_2
XFILLER_16_262 VGND VGND VPWR VPWR sky130_fd_sc_hd__fill_2
XPHY_EDGE_ROW_18_Left_67 VGND VGND VPWR VPWR sky130_fd_sc_hd__decap_3
XFILLER_13_24 VGND VGND VPWR VPWR sky130_fd_sc_hd__decap_3
XFILLER_13_57 VGND VGND VPWR VPWR sky130_fd_sc_hd__fill_1
XFILLER_22_221 VGND VGND VPWR VPWR sky130_fd_sc_hd__decap_3
XFILLER_22_276 VGND VGND VPWR VPWR sky130_fd_sc_hd__fill_2
Xfanout69 fanout70/X VGND VGND VPWR VPWR fanout69/X sky130_fd_sc_hd__clkdlybuf4s25_1
XTAP_TAPCELL_ROW_24_227 VGND VPWR sky130_fd_sc_hd__tapvpwrvgnd_1
XFILLER_1_125 VGND VGND VPWR VPWR sky130_fd_sc_hd__decap_3
XFILLER_1_169 VGND VGND VPWR VPWR sky130_fd_sc_hd__decap_3
XFILLER_38_65 VGND VGND VPWR VPWR sky130_fd_sc_hd__decap_3
XFILLER_13_254 VGND VGND VPWR VPWR sky130_fd_sc_hd__decap_3
XFILLER_9_225 VGND VGND VPWR VPWR sky130_fd_sc_hd__decap_3
XFILLER_9_269 VGND VGND VPWR VPWR sky130_fd_sc_hd__decap_3
X_1281_ clkload0/A _1281_/D wire68/X VGND VGND VPWR VPWR _1281_/Q sky130_fd_sc_hd__dfrtp_2
XFILLER_48_195 VGND VGND VPWR VPWR sky130_fd_sc_hd__fill_1
X_0996_ _0998_/B1 _0995_/Y _1004_/A VGND VGND VPWR VPWR _1047_/B sky130_fd_sc_hd__a21boi_2
XTAP_TAPCELL_ROW_21_208 VGND VPWR sky130_fd_sc_hd__tapvpwrvgnd_1
XFILLER_24_12 VGND VGND VPWR VPWR sky130_fd_sc_hd__decap_3
XFILLER_24_56 VGND VGND VPWR VPWR sky130_fd_sc_hd__decap_3
XFILLER_10_235 VGND VGND VPWR VPWR sky130_fd_sc_hd__decap_3
XFILLER_10_279 VGND VGND VPWR VPWR sky130_fd_sc_hd__decap_3
XFILLER_40_55 VGND VGND VPWR VPWR sky130_fd_sc_hd__decap_3
XFILLER_6_228 VGND VGND VPWR VPWR sky130_fd_sc_hd__decap_3
XFILLER_6_206 VGND VGND VPWR VPWR sky130_fd_sc_hd__decap_3
XFILLER_40_88 VGND VGND VPWR VPWR sky130_fd_sc_hd__decap_3
XFILLER_6_3 VGND VGND VPWR VPWR sky130_fd_sc_hd__decap_3
XFILLER_45_143 VGND VGND VPWR VPWR sky130_fd_sc_hd__decap_3
X_0850_ _0846_/A _0922_/B _0850_/B1 _0849_/Y VGND VGND VPWR VPWR _0850_/Y sky130_fd_sc_hd__o211ai_2
XTAP_TAPCELL_ROW_43_322 VGND VPWR sky130_fd_sc_hd__tapvpwrvgnd_1
X_0781_ _0781_/A _0783_/C VGND VGND VPWR VPWR _0781_/Y sky130_fd_sc_hd__nand2_2
XFILLER_39_3 VGND VGND VPWR VPWR sky130_fd_sc_hd__decap_3
X_1264_ clkload1/A _1264_/D fanout69/X VGND VGND VPWR VPWR _1264_/Q sky130_fd_sc_hd__dfrtp_2
Xinput4 a_in[3] VGND VGND VPWR VPWR input4/X sky130_fd_sc_hd__clkdlybuf4s25_1
XFILLER_36_176 VGND VGND VPWR VPWR sky130_fd_sc_hd__decap_3
X_1195_ _1259_/Q _1277_/Q VGND VGND VPWR VPWR _1200_/C sky130_fd_sc_hd__xor2_2
X_0979_ _0903_/B _0922_/B _0977_/X _1035_/B _0972_/Y VGND VGND VPWR VPWR _0979_/X
+ sky130_fd_sc_hd__o221a_2
XFILLER_19_12 VGND VGND VPWR VPWR sky130_fd_sc_hd__decap_3
XFILLER_19_45 VGND VGND VPWR VPWR sky130_fd_sc_hd__decap_3
XFILLER_19_67 VGND VGND VPWR VPWR sky130_fd_sc_hd__decap_3
XFILLER_19_89 VGND VGND VPWR VPWR sky130_fd_sc_hd__decap_3
XTAP_TAPCELL_ROW_40_303 VGND VPWR sky130_fd_sc_hd__tapvpwrvgnd_1
XFILLER_25_9 VGND VGND VPWR VPWR sky130_fd_sc_hd__decap_3
XFILLER_2_253 VGND VGND VPWR VPWR sky130_fd_sc_hd__decap_3
XFILLER_18_121 VGND VGND VPWR VPWR sky130_fd_sc_hd__decap_3
XFILLER_18_165 VGND VGND VPWR VPWR sky130_fd_sc_hd__decap_3
XFILLER_33_113 VGND VGND VPWR VPWR sky130_fd_sc_hd__decap_3
X_0902_ _0759_/A _0822_/Y _0900_/Y _0901_/Y VGND VGND VPWR VPWR _0973_/A sky130_fd_sc_hd__o211ai_4
X_0833_ _0759_/A _0903_/B _0824_/Y VGND VGND VPWR VPWR _0833_/Y sky130_fd_sc_hd__o21ai_4
X_0764_ _0846_/A _0903_/A VGND VGND VPWR VPWR _0766_/B sky130_fd_sc_hd__nor2_2
X_0695_ _1027_/A VGND VGND VPWR VPWR _1067_/A sky130_fd_sc_hd__buf_2
XFILLER_2_81 VGND VGND VPWR VPWR sky130_fd_sc_hd__decap_3
X_1178_ _1178_/A _1190_/A VGND VGND VPWR VPWR _1180_/A sky130_fd_sc_hd__nor2_2
X_1247_ _1247_/A _1247_/B _1247_/C VGND VGND VPWR VPWR _1248_/B sky130_fd_sc_hd__and3_2
XFILLER_32_190 VGND VGND VPWR VPWR sky130_fd_sc_hd__decap_3
XFILLER_21_57 VGND VGND VPWR VPWR sky130_fd_sc_hd__fill_1
XFILLER_15_113 VGND VGND VPWR VPWR sky130_fd_sc_hd__decap_3
XFILLER_46_65 VGND VGND VPWR VPWR sky130_fd_sc_hd__decap_3
XFILLER_47_249 VGND VGND VPWR VPWR sky130_fd_sc_hd__decap_3
XPHY_EDGE_ROW_6_Left_55 VGND VGND VPWR VPWR sky130_fd_sc_hd__decap_3
XFILLER_23_190 VGND VGND VPWR VPWR sky130_fd_sc_hd__decap_3
XFILLER_30_138 VGND VGND VPWR VPWR sky130_fd_sc_hd__fill_2
XFILLER_7_48 VGND VGND VPWR VPWR sky130_fd_sc_hd__decap_3
XFILLER_23_6 VGND VGND VPWR VPWR sky130_fd_sc_hd__decap_3
XFILLER_38_216 VGND VGND VPWR VPWR sky130_fd_sc_hd__decap_3
XFILLER_38_238 VGND VGND VPWR VPWR sky130_fd_sc_hd__decap_3
X_1101_ _1101_/A _1120_/B VGND VGND VPWR VPWR _1103_/C sky130_fd_sc_hd__and2_2
X_1032_ _1295_/Q _1104_/C _1075_/A _1075_/B VGND VGND VPWR VPWR _1038_/A sky130_fd_sc_hd__a22o_2
XFILLER_21_116 VGND VGND VPWR VPWR sky130_fd_sc_hd__decap_3
XFILLER_46_271 VGND VGND VPWR VPWR sky130_fd_sc_hd__decap_3
XTAP_TAPCELL_ROW_16_185 VGND VPWR sky130_fd_sc_hd__tapvpwrvgnd_1
X_0816_ _0816_/A _1289_/Q VGND VGND VPWR VPWR _0890_/A sky130_fd_sc_hd__nand2_8
X_0747_ _1023_/B _0820_/A _0746_/Y _0745_/Y VGND VGND VPWR VPWR _0747_/Y sky130_fd_sc_hd__a22oi_2
XFILLER_29_216 VGND VGND VPWR VPWR sky130_fd_sc_hd__fill_2
X_0678_ _1023_/A _1044_/A VGND VGND VPWR VPWR _0680_/A sky130_fd_sc_hd__nand2_2
XPHY_EDGE_ROW_48_Left_97 VGND VGND VPWR VPWR sky130_fd_sc_hd__decap_3
XFILLER_16_35 VGND VGND VPWR VPWR sky130_fd_sc_hd__decap_3
XFILLER_37_271 VGND VGND VPWR VPWR sky130_fd_sc_hd__decap_3
XTAP_TAPCELL_ROW_39_299 VGND VPWR sky130_fd_sc_hd__tapvpwrvgnd_1
XFILLER_12_116 VGND VGND VPWR VPWR sky130_fd_sc_hd__decap_3
XFILLER_12_138 VGND VGND VPWR VPWR sky130_fd_sc_hd__fill_2
XFILLER_32_45 VGND VGND VPWR VPWR sky130_fd_sc_hd__fill_1
XFILLER_8_109 VGND VGND VPWR VPWR sky130_fd_sc_hd__decap_3
XTAP_TAPCELL_ROW_7_142 VGND VPWR sky130_fd_sc_hd__tapvpwrvgnd_1
XFILLER_43_252 VGND VGND VPWR VPWR sky130_fd_sc_hd__decap_3
XFILLER_7_164 VGND VGND VPWR VPWR sky130_fd_sc_hd__decap_3
XFILLER_19_271 VGND VGND VPWR VPWR sky130_fd_sc_hd__decap_3
X_1015_ _1014_/X _1094_/C _0951_/Y _0952_/Y VGND VGND VPWR VPWR _1015_/X sky130_fd_sc_hd__o2bb2a_2
XFILLER_8_91 VGND VGND VPWR VPWR sky130_fd_sc_hd__decap_3
XTAP_TAPCELL_ROW_4_123 VGND VPWR sky130_fd_sc_hd__tapvpwrvgnd_1
XFILLER_40_200 VGND VGND VPWR VPWR sky130_fd_sc_hd__decap_3
XFILLER_40_244 VGND VGND VPWR VPWR sky130_fd_sc_hd__decap_3
XFILLER_43_44 VGND VGND VPWR VPWR sky130_fd_sc_hd__decap_3
XTAP_TAPCELL_ROW_35_280 VGND VPWR sky130_fd_sc_hd__tapvpwrvgnd_1
XFILLER_40_277 VGND VGND VPWR VPWR sky130_fd_sc_hd__fill_1
XFILLER_43_99 VGND VGND VPWR VPWR sky130_fd_sc_hd__decap_3
XFILLER_4_156 VGND VGND VPWR VPWR sky130_fd_sc_hd__decap_3
XFILLER_16_285 VGND VGND VPWR VPWR sky130_fd_sc_hd__fill_1
XFILLER_31_277 VGND VGND VPWR VPWR sky130_fd_sc_hd__decap_3
XFILLER_22_200 VGND VGND VPWR VPWR sky130_fd_sc_hd__decap_3
XFILLER_22_233 VGND VGND VPWR VPWR sky130_fd_sc_hd__decap_3
XFILLER_13_36 VGND VGND VPWR VPWR sky130_fd_sc_hd__decap_3
XFILLER_38_88 VGND VGND VPWR VPWR sky130_fd_sc_hd__decap_3
XFILLER_13_200 VGND VGND VPWR VPWR sky130_fd_sc_hd__decap_3
XPHY_EDGE_ROW_35_Left_84 VGND VGND VPWR VPWR sky130_fd_sc_hd__decap_3
XFILLER_9_215 VGND VGND VPWR VPWR sky130_fd_sc_hd__decap_3
XFILLER_0_192 VGND VGND VPWR VPWR sky130_fd_sc_hd__decap_3
XFILLER_48_141 VGND VGND VPWR VPWR sky130_fd_sc_hd__decap_3
X_1280_ clkload0/A _1280_/D wire68/X VGND VGND VPWR VPWR _1280_/Q sky130_fd_sc_hd__dfrtp_2
X_0995_ _0923_/B _0923_/A _0922_/A _0922_/B VGND VGND VPWR VPWR _0995_/Y sky130_fd_sc_hd__o2bb2ai_2
XTAP_TAPCELL_ROW_21_209 VGND VPWR sky130_fd_sc_hd__tapvpwrvgnd_1
XFILLER_5_70 VGND VGND VPWR VPWR sky130_fd_sc_hd__decap_3
XFILLER_39_130 VGND VGND VPWR VPWR sky130_fd_sc_hd__decap_3
XFILLER_10_203 VGND VGND VPWR VPWR sky130_fd_sc_hd__decap_3
XFILLER_10_214 VGND VGND VPWR VPWR sky130_fd_sc_hd__decap_3
XFILLER_24_24 VGND VGND VPWR VPWR sky130_fd_sc_hd__decap_3
XFILLER_24_35 VGND VGND VPWR VPWR sky130_fd_sc_hd__decap_3
XFILLER_24_68 VGND VGND VPWR VPWR sky130_fd_sc_hd__decap_3
XFILLER_40_45 VGND VGND VPWR VPWR sky130_fd_sc_hd__decap_3
XFILLER_1_28 VGND VGND VPWR VPWR sky130_fd_sc_hd__decap_3
X_0780_ _0722_/Y _0724_/X _0768_/Y VGND VGND VPWR VPWR _0783_/C sky130_fd_sc_hd__a21oi_4
XFILLER_5_284 VGND VGND VPWR VPWR sky130_fd_sc_hd__fill_2
XFILLER_5_273 VGND VGND VPWR VPWR sky130_fd_sc_hd__decap_3
XFILLER_36_122 VGND VGND VPWR VPWR sky130_fd_sc_hd__fill_1
XFILLER_36_144 VGND VGND VPWR VPWR sky130_fd_sc_hd__decap_3
X_1194_ _1190_/X _1255_/A2 _1193_/X wire55/X _1258_/Q VGND VGND VPWR VPWR _1258_/D
+ sky130_fd_sc_hd__a32o_2
X_1263_ _1305_/CLK _1263_/D fanout69/X VGND VGND VPWR VPWR _1263_/Q sky130_fd_sc_hd__dfrtp_2
Xinput5 a_in[4] VGND VGND VPWR VPWR input5/X sky130_fd_sc_hd__clkdlybuf4s25_1
XFILLER_36_155 VGND VGND VPWR VPWR sky130_fd_sc_hd__decap_3
XFILLER_10_37 VGND VGND VPWR VPWR sky130_fd_sc_hd__fill_1
X_0978_ _0978_/A _0978_/B _0978_/C VGND VGND VPWR VPWR _1035_/B sky130_fd_sc_hd__nand3_4
XFILLER_19_24 VGND VGND VPWR VPWR sky130_fd_sc_hd__fill_2
XFILLER_27_111 VGND VGND VPWR VPWR sky130_fd_sc_hd__fill_1
XFILLER_27_155 VGND VGND VPWR VPWR sky130_fd_sc_hd__decap_3
XFILLER_27_166 VGND VGND VPWR VPWR sky130_fd_sc_hd__fill_2
XFILLER_35_34 VGND VGND VPWR VPWR sky130_fd_sc_hd__decap_3
XFILLER_35_78 VGND VGND VPWR VPWR sky130_fd_sc_hd__decap_3
XFILLER_42_158 VGND VGND VPWR VPWR sky130_fd_sc_hd__decap_3
XTAP_TAPCELL_ROW_40_304 VGND VPWR sky130_fd_sc_hd__tapvpwrvgnd_1
XFILLER_18_100 VGND VGND VPWR VPWR sky130_fd_sc_hd__decap_3
XFILLER_18_133 VGND VGND VPWR VPWR sky130_fd_sc_hd__decap_3
XFILLER_18_9 VGND VGND VPWR VPWR sky130_fd_sc_hd__decap_3
XFILLER_18_144 VGND VGND VPWR VPWR sky130_fd_sc_hd__decap_3
XFILLER_18_177 VGND VGND VPWR VPWR sky130_fd_sc_hd__decap_3
XFILLER_33_125 VGND VGND VPWR VPWR sky130_fd_sc_hd__fill_1
X_0901_ _0890_/A _0889_/Y _0890_/Y VGND VGND VPWR VPWR _0901_/Y sky130_fd_sc_hd__o21ai_4
X_0832_ _0823_/Y _0821_/Y _0746_/Y VGND VGND VPWR VPWR _0832_/Y sky130_fd_sc_hd__a21oi_4
X_0763_ _1027_/A VGND VGND VPWR VPWR _0903_/A sky130_fd_sc_hd__inv_2
X_0694_ _1294_/Q VGND VGND VPWR VPWR _1027_/A sky130_fd_sc_hd__buf_2
XPHY_EDGE_ROW_22_Left_71 VGND VGND VPWR VPWR sky130_fd_sc_hd__decap_3
X_1177_ _1257_/Q _1275_/Q VGND VGND VPWR VPWR _1190_/A sky130_fd_sc_hd__and2_2
X_1246_ _1191_/B _1140_/A _1302_/Q _1245_/X _1247_/C VGND VGND VPWR VPWR _1302_/D
+ sky130_fd_sc_hd__a32o_2
XFILLER_24_136 VGND VGND VPWR VPWR sky130_fd_sc_hd__decap_3
XFILLER_24_147 VGND VGND VPWR VPWR sky130_fd_sc_hd__fill_2
XFILLER_24_169 VGND VGND VPWR VPWR sky130_fd_sc_hd__fill_2
XFILLER_46_33 VGND VGND VPWR VPWR sky130_fd_sc_hd__fill_2
XFILLER_47_206 VGND VGND VPWR VPWR sky130_fd_sc_hd__decap_3
XFILLER_47_228 VGND VGND VPWR VPWR sky130_fd_sc_hd__decap_3
XFILLER_15_125 VGND VGND VPWR VPWR sky130_fd_sc_hd__decap_3
XFILLER_46_88 VGND VGND VPWR VPWR sky130_fd_sc_hd__fill_1
Xmax_cap56 _1119_/A VGND VGND VPWR VPWR _0930_/B sky130_fd_sc_hd__buf_4
XFILLER_7_27 VGND VGND VPWR VPWR sky130_fd_sc_hd__decap_3
XFILLER_16_6 VGND VGND VPWR VPWR sky130_fd_sc_hd__decap_3
X_1100_ _1120_/C _1119_/D _1099_/X VGND VGND VPWR VPWR _1103_/B sky130_fd_sc_hd__a21o_2
X_1031_ _1028_/Y _1029_/X _1030_/Y VGND VGND VPWR VPWR _1075_/B sky130_fd_sc_hd__o21ai_2
XTAP_TAPCELL_ROW_16_186 VGND VPWR sky130_fd_sc_hd__tapvpwrvgnd_1
X_0815_ _0808_/Y _0813_/Y _0814_/Y VGND VGND VPWR VPWR _0819_/A sky130_fd_sc_hd__o21ba_4
X_0746_ split/A _0811_/B _0894_/B _0961_/C VGND VGND VPWR VPWR _0746_/Y sky130_fd_sc_hd__nand4_4
X_0677_ _0704_/A _1081_/C _0676_/Y _0659_/Y VGND VGND VPWR VPWR _0677_/X sky130_fd_sc_hd__a31o_4
X_1229_ _1264_/Q _1228_/X _1117_/A VGND VGND VPWR VPWR _1229_/Y sky130_fd_sc_hd__a21oi_2
XFILLER_12_128 VGND VGND VPWR VPWR sky130_fd_sc_hd__decap_3
XFILLER_20_161 VGND VGND VPWR VPWR sky130_fd_sc_hd__fill_1
XFILLER_43_231 VGND VGND VPWR VPWR sky130_fd_sc_hd__decap_3
XFILLER_43_264 VGND VGND VPWR VPWR sky130_fd_sc_hd__decap_3
XFILLER_11_172 VGND VGND VPWR VPWR sky130_fd_sc_hd__decap_3
XFILLER_26_209 VGND VGND VPWR VPWR sky130_fd_sc_hd__decap_3
XFILLER_34_220 VGND VGND VPWR VPWR sky130_fd_sc_hd__fill_2
X_1014_ _0948_/A _0946_/Y _1011_/Y VGND VGND VPWR VPWR _1014_/X sky130_fd_sc_hd__a21o_4
XFILLER_8_81 VGND VGND VPWR VPWR sky130_fd_sc_hd__decap_3
X_0729_ _0691_/X _0687_/A _0687_/B _0727_/Y _0787_/A VGND VGND VPWR VPWR _0735_/B
+ sky130_fd_sc_hd__o2111ai_2
XFILLER_27_46 VGND VGND VPWR VPWR sky130_fd_sc_hd__fill_2
XFILLER_27_57 VGND VGND VPWR VPWR sky130_fd_sc_hd__decap_3
XTAP_TAPCELL_ROW_4_124 VGND VPWR sky130_fd_sc_hd__tapvpwrvgnd_1
XFILLER_25_275 VGND VGND VPWR VPWR sky130_fd_sc_hd__decap_3
XFILLER_40_256 VGND VGND VPWR VPWR sky130_fd_sc_hd__decap_3
XFILLER_43_12 VGND VGND VPWR VPWR sky130_fd_sc_hd__decap_3
XFILLER_43_78 VGND VGND VPWR VPWR sky130_fd_sc_hd__decap_3
XTAP_TAPCELL_ROW_35_281 VGND VPWR sky130_fd_sc_hd__tapvpwrvgnd_1
XFILLER_16_220 VGND VGND VPWR VPWR sky130_fd_sc_hd__decap_3
XFILLER_16_253 VGND VGND VPWR VPWR sky130_fd_sc_hd__decap_3
XFILLER_31_234 VGND VGND VPWR VPWR sky130_fd_sc_hd__decap_3
XFILLER_13_15 VGND VGND VPWR VPWR sky130_fd_sc_hd__decap_3
XFILLER_22_212 VGND VGND VPWR VPWR sky130_fd_sc_hd__decap_3
XFILLER_22_245 VGND VGND VPWR VPWR sky130_fd_sc_hd__decap_3
XFILLER_22_256 VGND VGND VPWR VPWR sky130_fd_sc_hd__decap_3
XFILLER_13_48 VGND VGND VPWR VPWR sky130_fd_sc_hd__decap_3
XFILLER_1_105 VGND VGND VPWR VPWR sky130_fd_sc_hd__decap_3
XFILLER_1_116 VGND VGND VPWR VPWR sky130_fd_sc_hd__decap_3
XFILLER_48_175 VGND VGND VPWR VPWR sky130_fd_sc_hd__decap_3
XFILLER_48_153 VGND VGND VPWR VPWR sky130_fd_sc_hd__decap_3
XFILLER_48_197 VGND VGND VPWR VPWR sky130_fd_sc_hd__decap_3
X_0994_ _1047_/A _1049_/A VGND VGND VPWR VPWR _1003_/A sky130_fd_sc_hd__nand2_2
XFILLER_5_93 VGND VGND VPWR VPWR sky130_fd_sc_hd__decap_3
XFILLER_5_82 VGND VGND VPWR VPWR sky130_fd_sc_hd__decap_3
XFILLER_5_60 VGND VGND VPWR VPWR sky130_fd_sc_hd__fill_1
XFILLER_39_186 VGND VGND VPWR VPWR sky130_fd_sc_hd__decap_3
XFILLER_10_226 VGND VGND VPWR VPWR sky130_fd_sc_hd__decap_3
XFILLER_24_47 VGND VGND VPWR VPWR sky130_fd_sc_hd__decap_3
XFILLER_14_80 VGND VGND VPWR VPWR sky130_fd_sc_hd__decap_3
XFILLER_14_91 VGND VGND VPWR VPWR sky130_fd_sc_hd__decap_3
XFILLER_5_241 VGND VGND VPWR VPWR sky130_fd_sc_hd__decap_3
XFILLER_36_167 VGND VGND VPWR VPWR sky130_fd_sc_hd__decap_3
X_1193_ _1193_/A1 _1199_/A _1187_/B _1187_/A VGND VGND VPWR VPWR _1193_/X sky130_fd_sc_hd__a211o_2
X_1262_ clkload1/A _1262_/D fanout69/X VGND VGND VPWR VPWR _1262_/Q sky130_fd_sc_hd__dfrtp_2
Xinput6 a_in[5] VGND VGND VPWR VPWR input6/X sky130_fd_sc_hd__clkdlybuf4s25_1
X_0977_ _0977_/A _0977_/B _0977_/C VGND VGND VPWR VPWR _0977_/X sky130_fd_sc_hd__and3_2
XFILLER_19_36 VGND VGND VPWR VPWR sky130_fd_sc_hd__decap_3
XFILLER_27_101 VGND VGND VPWR VPWR sky130_fd_sc_hd__decap_3
XFILLER_35_24 VGND VGND VPWR VPWR sky130_fd_sc_hd__decap_3
XFILLER_35_57 VGND VGND VPWR VPWR sky130_fd_sc_hd__decap_3
Xclkbuf_3_3__f_clk clkbuf_0_clk/X VGND VGND VPWR VPWR clkload2/A sky130_fd_sc_hd__clkbuf_16
XTAP_TAPCELL_ROW_40_305 VGND VPWR sky130_fd_sc_hd__tapvpwrvgnd_1
XPHY_EDGE_ROW_14_Right_14 VGND VGND VPWR VPWR sky130_fd_sc_hd__decap_3
XFILLER_2_200 VGND VGND VPWR VPWR sky130_fd_sc_hd__decap_3
XPHY_EDGE_ROW_23_Right_23 VGND VGND VPWR VPWR sky130_fd_sc_hd__decap_3
XFILLER_18_112 VGND VGND VPWR VPWR sky130_fd_sc_hd__decap_3
XFILLER_18_156 VGND VGND VPWR VPWR sky130_fd_sc_hd__decap_3
XFILLER_18_189 VGND VGND VPWR VPWR sky130_fd_sc_hd__decap_3
XFILLER_33_104 VGND VGND VPWR VPWR sky130_fd_sc_hd__decap_3
XFILLER_41_181 VGND VGND VPWR VPWR sky130_fd_sc_hd__decap_3
X_0900_ _0900_/A _1023_/B _1070_/A _1024_/A VGND VGND VPWR VPWR _0900_/Y sky130_fd_sc_hd__nand4_4
XPHY_EDGE_ROW_32_Right_32 VGND VGND VPWR VPWR sky130_fd_sc_hd__decap_3
X_0831_ _0821_/Y _0823_/Y _0746_/Y VGND VGND VPWR VPWR _0831_/Y sky130_fd_sc_hd__a21boi_2
X_0762_ _0771_/A _0771_/B _0841_/A VGND VGND VPWR VPWR _0766_/A sky130_fd_sc_hd__a21o_2
X_0693_ _0687_/A _0691_/X _0692_/Y VGND VGND VPWR VPWR _0697_/B sky130_fd_sc_hd__a21oi_2
XFILLER_44_3 VGND VGND VPWR VPWR sky130_fd_sc_hd__decap_3
XPHY_EDGE_ROW_41_Right_41 VGND VGND VPWR VPWR sky130_fd_sc_hd__decap_3
X_1176_ _1257_/Q _1275_/Q VGND VGND VPWR VPWR _1178_/A sky130_fd_sc_hd__nor2_2
X_1245_ _1165_/B _1165_/A _0630_/A _1182_/A VGND VGND VPWR VPWR _1245_/X sky130_fd_sc_hd__o211a_2
XFILLER_32_181 VGND VGND VPWR VPWR sky130_fd_sc_hd__decap_3
XFILLER_46_56 VGND VGND VPWR VPWR sky130_fd_sc_hd__decap_3
XFILLER_47_218 VGND VGND VPWR VPWR sky130_fd_sc_hd__decap_3
XFILLER_15_104 VGND VGND VPWR VPWR sky130_fd_sc_hd__decap_3
XFILLER_15_159 VGND VGND VPWR VPWR sky130_fd_sc_hd__decap_3
XFILLER_23_181 VGND VGND VPWR VPWR sky130_fd_sc_hd__fill_1
XFILLER_30_129 VGND VGND VPWR VPWR sky130_fd_sc_hd__decap_3
Xmax_cap57 _0642_/D VGND VGND VPWR VPWR _0940_/A sky130_fd_sc_hd__buf_2
XFILLER_7_39 VGND VGND VPWR VPWR sky130_fd_sc_hd__decap_3
XFILLER_30_9 VGND VGND VPWR VPWR sky130_fd_sc_hd__decap_3
XFILLER_38_207 VGND VGND VPWR VPWR sky130_fd_sc_hd__decap_3
XFILLER_46_251 VGND VGND VPWR VPWR sky130_fd_sc_hd__fill_1
XFILLER_46_262 VGND VGND VPWR VPWR sky130_fd_sc_hd__decap_3
X_1030_ _0759_/A _1030_/A2 _1023_/Y _0961_/Y VGND VGND VPWR VPWR _1030_/Y sky130_fd_sc_hd__o211ai_2
XFILLER_14_192 VGND VGND VPWR VPWR sky130_fd_sc_hd__decap_3
X_0814_ _0814_/A _0820_/A VGND VGND VPWR VPWR _0814_/Y sky130_fd_sc_hd__nand2_2
XTAP_TAPCELL_ROW_16_187 VGND VPWR sky130_fd_sc_hd__tapvpwrvgnd_1
X_0745_ _0745_/A _0888_/A VGND VGND VPWR VPWR _0745_/Y sky130_fd_sc_hd__nand2_2
X_0676_ _1098_/A _1284_/Q VGND VGND VPWR VPWR _0676_/Y sky130_fd_sc_hd__nand2_2
XFILLER_29_207 VGND VGND VPWR VPWR sky130_fd_sc_hd__decap_3
X_1228_ _1224_/B _1225_/X _1147_/X VGND VGND VPWR VPWR _1228_/X sky130_fd_sc_hd__o21a_2
XFILLER_16_26 VGND VGND VPWR VPWR sky130_fd_sc_hd__fill_2
XFILLER_37_262 VGND VGND VPWR VPWR sky130_fd_sc_hd__decap_3
XFILLER_37_284 VGND VGND VPWR VPWR sky130_fd_sc_hd__fill_2
X_1159_ _1300_/Q _1268_/Q VGND VGND VPWR VPWR _1159_/X sky130_fd_sc_hd__or2_4
XFILLER_20_184 VGND VGND VPWR VPWR sky130_fd_sc_hd__fill_1
XFILLER_28_240 VGND VGND VPWR VPWR sky130_fd_sc_hd__decap_3
XFILLER_43_221 VGND VGND VPWR VPWR sky130_fd_sc_hd__decap_3
XFILLER_43_243 VGND VGND VPWR VPWR sky130_fd_sc_hd__decap_3
XFILLER_11_140 VGND VGND VPWR VPWR sky130_fd_sc_hd__decap_3
XFILLER_43_276 VGND VGND VPWR VPWR sky130_fd_sc_hd__decap_3
XTAP_TAPCELL_ROW_13_168 VGND VPWR sky130_fd_sc_hd__tapvpwrvgnd_1
XFILLER_22_91 VGND VGND VPWR VPWR sky130_fd_sc_hd__fill_1
XFILLER_7_199 VGND VGND VPWR VPWR sky130_fd_sc_hd__decap_3
XFILLER_19_262 VGND VGND VPWR VPWR sky130_fd_sc_hd__decap_3
XFILLER_19_284 VGND VGND VPWR VPWR sky130_fd_sc_hd__fill_2
XFILLER_34_243 VGND VGND VPWR VPWR sky130_fd_sc_hd__decap_3
XFILLER_34_276 VGND VGND VPWR VPWR sky130_fd_sc_hd__fill_2
X_1013_ _0946_/Y _0938_/X _0950_/Y _1094_/C VGND VGND VPWR VPWR _1013_/X sky130_fd_sc_hd__o211a_2
XFILLER_8_60 VGND VGND VPWR VPWR sky130_fd_sc_hd__decap_3
X_0728_ _0940_/A _1067_/A _0727_/B _0727_/A VGND VGND VPWR VPWR _0787_/A sky130_fd_sc_hd__a22o_4
X_0659_ _1023_/A _1024_/A _1284_/Q _1044_/A VGND VGND VPWR VPWR _0659_/Y sky130_fd_sc_hd__nand4_4
XPHY_EDGE_ROW_4_Right_4 VGND VGND VPWR VPWR sky130_fd_sc_hd__decap_3
XTAP_TAPCELL_ROW_4_125 VGND VPWR sky130_fd_sc_hd__tapvpwrvgnd_1
XTAP_TAPCELL_ROW_27_238 VGND VPWR sky130_fd_sc_hd__tapvpwrvgnd_1
XFILLER_40_235 VGND VGND VPWR VPWR sky130_fd_sc_hd__decap_3
XFILLER_40_268 VGND VGND VPWR VPWR sky130_fd_sc_hd__decap_3
XTAP_TAPCELL_ROW_35_282 VGND VPWR sky130_fd_sc_hd__tapvpwrvgnd_1
XFILLER_4_29 VGND VGND VPWR VPWR sky130_fd_sc_hd__decap_3
XFILLER_4_18 VGND VGND VPWR VPWR sky130_fd_sc_hd__decap_3
XFILLER_4_147 VGND VGND VPWR VPWR sky130_fd_sc_hd__decap_3
XFILLER_17_80 VGND VGND VPWR VPWR sky130_fd_sc_hd__decap_3
XFILLER_13_27 VGND VGND VPWR VPWR sky130_fd_sc_hd__decap_3
XFILLER_22_224 VGND VGND VPWR VPWR sky130_fd_sc_hd__decap_3
XTAP_TAPCELL_ROW_32_263 VGND VPWR sky130_fd_sc_hd__tapvpwrvgnd_1
XFILLER_1_128 VGND VGND VPWR VPWR sky130_fd_sc_hd__decap_3
XFILLER_13_257 VGND VGND VPWR VPWR sky130_fd_sc_hd__fill_2
XFILLER_9_228 VGND VGND VPWR VPWR sky130_fd_sc_hd__decap_3
XTAP_TAPCELL_ROW_46_333 VGND VPWR sky130_fd_sc_hd__tapvpwrvgnd_1
X_0993_ _0993_/A _0993_/B _0993_/C VGND VGND VPWR VPWR _1049_/A sky130_fd_sc_hd__nand3_4
XFILLER_39_121 VGND VGND VPWR VPWR sky130_fd_sc_hd__decap_3
XFILLER_5_50 VGND VGND VPWR VPWR sky130_fd_sc_hd__fill_1
XFILLER_24_15 VGND VGND VPWR VPWR sky130_fd_sc_hd__decap_3
XFILLER_10_238 VGND VGND VPWR VPWR sky130_fd_sc_hd__fill_1
XFILLER_24_59 VGND VGND VPWR VPWR sky130_fd_sc_hd__decap_3
XFILLER_6_209 VGND VGND VPWR VPWR sky130_fd_sc_hd__decap_3
XFILLER_40_58 VGND VGND VPWR VPWR sky130_fd_sc_hd__fill_1
XFILLER_6_6 VGND VGND VPWR VPWR sky130_fd_sc_hd__decap_3
XFILLER_1_19 VGND VGND VPWR VPWR sky130_fd_sc_hd__decap_3
XFILLER_45_113 VGND VGND VPWR VPWR sky130_fd_sc_hd__decap_3
XFILLER_45_146 VGND VGND VPWR VPWR sky130_fd_sc_hd__decap_3
XFILLER_30_91 VGND VGND VPWR VPWR sky130_fd_sc_hd__fill_1
XFILLER_39_6 VGND VGND VPWR VPWR sky130_fd_sc_hd__decap_3
X_1261_ _1305_/CLK _1261_/D fanout69/X VGND VGND VPWR VPWR _1261_/Q sky130_fd_sc_hd__dfrtp_2
XFILLER_36_113 VGND VGND VPWR VPWR sky130_fd_sc_hd__decap_3
XFILLER_36_135 VGND VGND VPWR VPWR sky130_fd_sc_hd__decap_3
XFILLER_36_179 VGND VGND VPWR VPWR sky130_fd_sc_hd__decap_3
X_1192_ _1257_/Q _1275_/Q _1190_/C VGND VGND VPWR VPWR _1199_/A sky130_fd_sc_hd__a21oi_2
Xinput7 a_in[6] VGND VGND VPWR VPWR input7/X sky130_fd_sc_hd__clkdlybuf4s25_1
X_0976_ _0972_/Y _0974_/Y _0975_/Y VGND VGND VPWR VPWR _0976_/Y sky130_fd_sc_hd__a21oi_2
XFILLER_19_15 VGND VGND VPWR VPWR sky130_fd_sc_hd__decap_3
XFILLER_19_48 VGND VGND VPWR VPWR sky130_fd_sc_hd__decap_3
XTAP_TAPCELL_ROW_40_306 VGND VPWR sky130_fd_sc_hd__tapvpwrvgnd_1
XFILLER_2_256 VGND VGND VPWR VPWR sky130_fd_sc_hd__fill_2
XFILLER_4_3 VGND VGND VPWR VPWR sky130_fd_sc_hd__decap_3
XFILLER_18_124 VGND VGND VPWR VPWR sky130_fd_sc_hd__decap_3
XFILLER_18_168 VGND VGND VPWR VPWR sky130_fd_sc_hd__fill_1
XFILLER_25_91 VGND VGND VPWR VPWR sky130_fd_sc_hd__decap_3
X_0830_ _0808_/Y _0813_/Y _0814_/Y VGND VGND VPWR VPWR _0830_/Y sky130_fd_sc_hd__o21bai_2
XFILLER_41_90 VGND VGND VPWR VPWR sky130_fd_sc_hd__fill_1
X_0761_ _0683_/B _0716_/Y _0712_/Y VGND VGND VPWR VPWR _0841_/A sky130_fd_sc_hd__o21ai_4
X_0692_ _0687_/A _0691_/X _0687_/B VGND VGND VPWR VPWR _0692_/Y sky130_fd_sc_hd__o21ai_2
XFILLER_2_51 VGND VGND VPWR VPWR sky130_fd_sc_hd__fill_1
XFILLER_37_3 VGND VGND VPWR VPWR sky130_fd_sc_hd__decap_3
X_1244_ _1242_/X _1243_/Y _1255_/A2 _1301_/Q wire55/X VGND VGND VPWR VPWR _1301_/D
+ sky130_fd_sc_hd__a32o_2
XFILLER_17_190 VGND VGND VPWR VPWR sky130_fd_sc_hd__decap_3
X_1175_ _1191_/B _1140_/A _1256_/Q _1173_/X _1174_/Y VGND VGND VPWR VPWR _1256_/D
+ sky130_fd_sc_hd__a32o_2
XFILLER_32_193 VGND VGND VPWR VPWR sky130_fd_sc_hd__decap_3
X_0959_ _1029_/C _0961_/C VGND VGND VPWR VPWR _0960_/B sky130_fd_sc_hd__nand2_2
XFILLER_15_116 VGND VGND VPWR VPWR sky130_fd_sc_hd__decap_3
XFILLER_46_24 VGND VGND VPWR VPWR sky130_fd_sc_hd__decap_3
XFILLER_46_68 VGND VGND VPWR VPWR sky130_fd_sc_hd__decap_3
Xmax_cap58 _1001_/D VGND VGND VPWR VPWR _1119_/C sky130_fd_sc_hd__buf_4
XFILLER_23_193 VGND VGND VPWR VPWR sky130_fd_sc_hd__decap_3
XFILLER_11_60 VGND VGND VPWR VPWR sky130_fd_sc_hd__decap_3
XFILLER_23_9 VGND VGND VPWR VPWR sky130_fd_sc_hd__decap_3
XFILLER_38_219 VGND VGND VPWR VPWR sky130_fd_sc_hd__fill_2
XFILLER_46_230 VGND VGND VPWR VPWR sky130_fd_sc_hd__decap_3
XFILLER_46_274 VGND VGND VPWR VPWR sky130_fd_sc_hd__decap_3
XFILLER_14_160 VGND VGND VPWR VPWR sky130_fd_sc_hd__fill_2
XFILLER_21_119 VGND VGND VPWR VPWR sky130_fd_sc_hd__decap_3
Xinput10 b_in[1] VGND VGND VPWR VPWR _1291_/D sky130_fd_sc_hd__clkdlybuf4s25_1
X_0813_ _0811_/Y _0810_/Y _0812_/X VGND VGND VPWR VPWR _0813_/Y sky130_fd_sc_hd__a21oi_4
X_0744_ _0811_/B _0961_/C VGND VGND VPWR VPWR _0888_/A sky130_fd_sc_hd__nand2_4
X_0675_ _0820_/A VGND VGND VPWR VPWR _1081_/C sky130_fd_sc_hd__buf_2
XFILLER_37_274 VGND VGND VPWR VPWR sky130_fd_sc_hd__decap_3
X_1158_ _1236_/A _1236_/B _1236_/C VGND VGND VPWR VPWR _1158_/Y sky130_fd_sc_hd__o21bai_4
X_1227_ _1225_/X _1226_/Y _1263_/Q _1183_/A VGND VGND VPWR VPWR _1263_/D sky130_fd_sc_hd__a2bb2o_2
XFILLER_12_119 VGND VGND VPWR VPWR sky130_fd_sc_hd__decap_3
X_1089_ _1063_/Y _1064_/Y _1090_/A _1090_/B VGND VGND VPWR VPWR _1089_/X sky130_fd_sc_hd__a2bb2o_2
XFILLER_43_255 VGND VGND VPWR VPWR sky130_fd_sc_hd__decap_3
XTAP_TAPCELL_ROW_13_169 VGND VPWR sky130_fd_sc_hd__tapvpwrvgnd_1
XFILLER_7_134 VGND VGND VPWR VPWR sky130_fd_sc_hd__decap_3
XFILLER_22_81 VGND VGND VPWR VPWR sky130_fd_sc_hd__decap_3
XFILLER_7_167 VGND VGND VPWR VPWR sky130_fd_sc_hd__fill_1
XFILLER_19_274 VGND VGND VPWR VPWR sky130_fd_sc_hd__decap_3
XFILLER_34_200 VGND VGND VPWR VPWR sky130_fd_sc_hd__decap_3
X_1012_ _0956_/Y _0949_/Y _0948_/A _1011_/Y VGND VGND VPWR VPWR _1059_/C sky130_fd_sc_hd__o211ai_4
X_0727_ _0727_/A _0727_/B _0940_/A _1067_/A VGND VGND VPWR VPWR _0727_/Y sky130_fd_sc_hd__nand4_2
XFILLER_8_94 VGND VGND VPWR VPWR sky130_fd_sc_hd__decap_3
XFILLER_8_72 VGND VGND VPWR VPWR sky130_fd_sc_hd__decap_3
X_0658_ _1023_/A _1284_/Q _1044_/A _0704_/A VGND VGND VPWR VPWR _0660_/A sky130_fd_sc_hd__a22o_2
XTAP_TAPCELL_ROW_4_126 VGND VPWR sky130_fd_sc_hd__tapvpwrvgnd_1
XTAP_TAPCELL_ROW_27_239 VGND VPWR sky130_fd_sc_hd__tapvpwrvgnd_1
XFILLER_40_203 VGND VGND VPWR VPWR sky130_fd_sc_hd__fill_2
XFILLER_40_247 VGND VGND VPWR VPWR sky130_fd_sc_hd__decap_3
XFILLER_43_47 VGND VGND VPWR VPWR sky130_fd_sc_hd__decap_3
XFILLER_4_159 VGND VGND VPWR VPWR sky130_fd_sc_hd__fill_2
XFILLER_16_211 VGND VGND VPWR VPWR sky130_fd_sc_hd__decap_3
XFILLER_17_92 VGND VGND VPWR VPWR sky130_fd_sc_hd__decap_3
XFILLER_31_225 VGND VGND VPWR VPWR sky130_fd_sc_hd__decap_3
XFILLER_13_39 VGND VGND VPWR VPWR sky130_fd_sc_hd__decap_3
XFILLER_22_203 VGND VGND VPWR VPWR sky130_fd_sc_hd__decap_3
XFILLER_22_236 VGND VGND VPWR VPWR sky130_fd_sc_hd__decap_3
XFILLER_30_280 VGND VGND VPWR VPWR sky130_fd_sc_hd__decap_3
XTAP_TAPCELL_ROW_32_264 VGND VPWR sky130_fd_sc_hd__tapvpwrvgnd_1
XFILLER_13_225 VGND VGND VPWR VPWR sky130_fd_sc_hd__fill_1
XTAP_TAPCELL_ROW_23_220 VGND VPWR sky130_fd_sc_hd__tapvpwrvgnd_1
XFILLER_9_218 VGND VGND VPWR VPWR sky130_fd_sc_hd__decap_3
XFILLER_0_195 VGND VGND VPWR VPWR sky130_fd_sc_hd__fill_1
XFILLER_48_144 VGND VGND VPWR VPWR sky130_fd_sc_hd__decap_3
XTAP_TAPCELL_ROW_46_334 VGND VPWR sky130_fd_sc_hd__tapvpwrvgnd_1
XFILLER_48_166 VGND VGND VPWR VPWR sky130_fd_sc_hd__fill_2
X_0992_ _0991_/A _0991_/B _0976_/Y _0979_/X VGND VGND VPWR VPWR _0993_/C sky130_fd_sc_hd__o2bb2ai_2
XFILLER_8_262 VGND VGND VPWR VPWR sky130_fd_sc_hd__decap_3
XFILLER_5_73 VGND VGND VPWR VPWR sky130_fd_sc_hd__decap_3
XFILLER_39_133 VGND VGND VPWR VPWR sky130_fd_sc_hd__decap_3
XFILLER_39_166 VGND VGND VPWR VPWR sky130_fd_sc_hd__fill_2
XFILLER_24_27 VGND VGND VPWR VPWR sky130_fd_sc_hd__fill_1
XFILLER_24_38 VGND VGND VPWR VPWR sky130_fd_sc_hd__decap_3
XFILLER_10_206 VGND VGND VPWR VPWR sky130_fd_sc_hd__decap_3
XFILLER_10_217 VGND VGND VPWR VPWR sky130_fd_sc_hd__decap_3
XPHY_EDGE_ROW_39_Left_88 VGND VGND VPWR VPWR sky130_fd_sc_hd__decap_3
XFILLER_14_71 VGND VGND VPWR VPWR sky130_fd_sc_hd__decap_3
XFILLER_30_81 VGND VGND VPWR VPWR sky130_fd_sc_hd__decap_3
XFILLER_5_276 VGND VGND VPWR VPWR sky130_fd_sc_hd__decap_3
XFILLER_5_232 VGND VGND VPWR VPWR sky130_fd_sc_hd__decap_3
XFILLER_5_221 VGND VGND VPWR VPWR sky130_fd_sc_hd__decap_3
X_1191_ _1191_/A _1191_/B VGND VGND VPWR VPWR _1191_/Y sky130_fd_sc_hd__nor2_2
X_1260_ _1305_/CLK _1260_/D fanout69/X VGND VGND VPWR VPWR _1260_/Q sky130_fd_sc_hd__dfrtp_2
Xinput8 a_in[7] VGND VGND VPWR VPWR input8/X sky130_fd_sc_hd__clkdlybuf4s25_1
XFILLER_36_147 VGND VGND VPWR VPWR sky130_fd_sc_hd__decap_3
XFILLER_36_158 VGND VGND VPWR VPWR sky130_fd_sc_hd__decap_3
X_0975_ _1081_/C _0985_/D VGND VGND VPWR VPWR _0975_/Y sky130_fd_sc_hd__nand2_2
XFILLER_35_15 VGND VGND VPWR VPWR sky130_fd_sc_hd__decap_3
XFILLER_27_169 VGND VGND VPWR VPWR sky130_fd_sc_hd__fill_1
XFILLER_35_180 VGND VGND VPWR VPWR sky130_fd_sc_hd__decap_3
XFILLER_35_37 VGND VGND VPWR VPWR sky130_fd_sc_hd__decap_3
XFILLER_42_139 VGND VGND VPWR VPWR sky130_fd_sc_hd__fill_1
XTAP_TAPCELL_ROW_40_307 VGND VPWR sky130_fd_sc_hd__tapvpwrvgnd_1
XFILLER_18_103 VGND VGND VPWR VPWR sky130_fd_sc_hd__fill_1
XFILLER_18_136 VGND VGND VPWR VPWR sky130_fd_sc_hd__decap_3
XFILLER_18_147 VGND VGND VPWR VPWR sky130_fd_sc_hd__decap_3
XFILLER_25_81 VGND VGND VPWR VPWR sky130_fd_sc_hd__fill_1
XFILLER_41_172 VGND VGND VPWR VPWR sky130_fd_sc_hd__decap_3
X_0760_ _0760_/A _0760_/B _0760_/C VGND VGND VPWR VPWR _0771_/B sky130_fd_sc_hd__nand3_4
X_0691_ _0688_/X _0685_/Y _0778_/A _0759_/A VGND VGND VPWR VPWR _0691_/X sky130_fd_sc_hd__o2bb2a_4
XFILLER_2_85 VGND VGND VPWR VPWR sky130_fd_sc_hd__fill_2
X_1174_ _1174_/A _1174_/B VGND VGND VPWR VPWR _1174_/Y sky130_fd_sc_hd__nand2_2
X_1243_ _1242_/A _1242_/B _1242_/C VGND VGND VPWR VPWR _1243_/Y sky130_fd_sc_hd__o21ai_2
XFILLER_24_139 VGND VGND VPWR VPWR sky130_fd_sc_hd__fill_1
X_0958_ _0958_/A _0967_/C VGND VGND VPWR VPWR _0960_/A sky130_fd_sc_hd__nand2_2
X_0889_ _0811_/B _0958_/A _0961_/C VGND VGND VPWR VPWR _0889_/Y sky130_fd_sc_hd__o21ai_2
XFILLER_47_209 VGND VGND VPWR VPWR sky130_fd_sc_hd__decap_3
XFILLER_15_128 VGND VGND VPWR VPWR sky130_fd_sc_hd__decap_3
Xmax_cap59 _1101_/A VGND VGND VPWR VPWR _1036_/D sky130_fd_sc_hd__buf_2
XFILLER_23_161 VGND VGND VPWR VPWR sky130_fd_sc_hd__decap_3
XFILLER_23_172 VGND VGND VPWR VPWR sky130_fd_sc_hd__decap_3
XFILLER_16_9 VGND VGND VPWR VPWR sky130_fd_sc_hd__fill_2
XFILLER_46_242 VGND VGND VPWR VPWR sky130_fd_sc_hd__decap_3
XFILLER_36_80 VGND VGND VPWR VPWR sky130_fd_sc_hd__decap_3
XFILLER_46_253 VGND VGND VPWR VPWR sky130_fd_sc_hd__decap_3
Xinput11 b_in[2] VGND VGND VPWR VPWR _1292_/D sky130_fd_sc_hd__clkdlybuf4s25_1
X_0812_ _0958_/A _0894_/B VGND VGND VPWR VPWR _0812_/X sky130_fd_sc_hd__and2_2
X_0743_ _1288_/Q VGND VGND VPWR VPWR _0961_/C sky130_fd_sc_hd__buf_12
XPHY_EDGE_ROW_26_Left_75 VGND VGND VPWR VPWR sky130_fd_sc_hd__decap_3
X_0674_ _1286_/Q VGND VGND VPWR VPWR _0820_/A sky130_fd_sc_hd__buf_4
XPHY_EDGE_ROW_10_Left_59 VGND VGND VPWR VPWR sky130_fd_sc_hd__decap_3
XFILLER_37_231 VGND VGND VPWR VPWR sky130_fd_sc_hd__decap_3
X_1157_ _1299_/Q _1267_/Q VGND VGND VPWR VPWR _1236_/C sky130_fd_sc_hd__and2_4
X_1226_ _1218_/B _1221_/Y _1224_/Y _1255_/A2 VGND VGND VPWR VPWR _1226_/Y sky130_fd_sc_hd__o31ai_2
X_1088_ _1088_/A1 _1085_/A _1087_/Y VGND VGND VPWR VPWR _1090_/B sky130_fd_sc_hd__o21ai_4
XFILLER_20_197 VGND VGND VPWR VPWR sky130_fd_sc_hd__decap_3
XFILLER_43_234 VGND VGND VPWR VPWR sky130_fd_sc_hd__decap_3
XFILLER_43_267 VGND VGND VPWR VPWR sky130_fd_sc_hd__decap_3
XFILLER_11_175 VGND VGND VPWR VPWR sky130_fd_sc_hd__decap_3
X_1011_ _1011_/A _1011_/B VGND VGND VPWR VPWR _1011_/Y sky130_fd_sc_hd__nand2_4
X_0726_ _0723_/Y _0726_/A2 _0768_/A _0726_/C1 VGND VGND VPWR VPWR _0727_/B sky130_fd_sc_hd__o211ai_4
XFILLER_6_190 VGND VGND VPWR VPWR sky130_fd_sc_hd__decap_3
X_0657_ _1285_/Q VGND VGND VPWR VPWR _1044_/A sky130_fd_sc_hd__buf_4
XTAP_TAPCELL_ROW_4_127 VGND VPWR sky130_fd_sc_hd__tapvpwrvgnd_1
XFILLER_25_278 VGND VGND VPWR VPWR sky130_fd_sc_hd__fill_2
XFILLER_43_15 VGND VGND VPWR VPWR sky130_fd_sc_hd__decap_3
X_1209_ _1261_/Q _1279_/Q VGND VGND VPWR VPWR _1211_/C sky130_fd_sc_hd__xor2_2
XFILLER_40_259 VGND VGND VPWR VPWR sky130_fd_sc_hd__decap_3
XFILLER_16_223 VGND VGND VPWR VPWR sky130_fd_sc_hd__decap_3
XFILLER_16_256 VGND VGND VPWR VPWR sky130_fd_sc_hd__decap_3
XFILLER_17_60 VGND VGND VPWR VPWR sky130_fd_sc_hd__decap_3
XFILLER_31_237 VGND VGND VPWR VPWR sky130_fd_sc_hd__decap_3
XFILLER_12_3 VGND VGND VPWR VPWR sky130_fd_sc_hd__decap_3
XFILLER_22_215 VGND VGND VPWR VPWR sky130_fd_sc_hd__decap_3
XTAP_TAPCELL_ROW_1_108 VGND VPWR sky130_fd_sc_hd__tapvpwrvgnd_1
XFILLER_13_18 VGND VGND VPWR VPWR sky130_fd_sc_hd__decap_3
XFILLER_22_248 VGND VGND VPWR VPWR sky130_fd_sc_hd__decap_3
XTAP_TAPCELL_ROW_32_265 VGND VPWR sky130_fd_sc_hd__tapvpwrvgnd_1
XFILLER_1_108 VGND VGND VPWR VPWR sky130_fd_sc_hd__decap_3
XFILLER_1_119 VGND VGND VPWR VPWR sky130_fd_sc_hd__decap_3
X_0709_ _0713_/B _0713_/C VGND VGND VPWR VPWR _0711_/A sky130_fd_sc_hd__nand2_2
XPHY_EDGE_ROW_13_Left_62 VGND VGND VPWR VPWR sky130_fd_sc_hd__decap_3
XTAP_TAPCELL_ROW_23_221 VGND VPWR sky130_fd_sc_hd__tapvpwrvgnd_1
XFILLER_21_281 VGND VGND VPWR VPWR sky130_fd_sc_hd__decap_3
XTAP_TAPCELL_ROW_46_335 VGND VPWR sky130_fd_sc_hd__tapvpwrvgnd_1
XFILLER_48_178 VGND VGND VPWR VPWR sky130_fd_sc_hd__decap_3
XFILLER_48_156 VGND VGND VPWR VPWR sky130_fd_sc_hd__fill_2
XFILLER_12_281 VGND VGND VPWR VPWR sky130_fd_sc_hd__decap_3
X_0991_ _0991_/A _0991_/B _0991_/C _0991_/D VGND VGND VPWR VPWR _0993_/A sky130_fd_sc_hd__nand4_4
XFILLER_8_241 VGND VGND VPWR VPWR sky130_fd_sc_hd__decap_3
XFILLER_5_96 VGND VGND VPWR VPWR sky130_fd_sc_hd__decap_3
XFILLER_39_189 VGND VGND VPWR VPWR sky130_fd_sc_hd__fill_2
XFILLER_10_229 VGND VGND VPWR VPWR sky130_fd_sc_hd__decap_3
XFILLER_14_83 VGND VGND VPWR VPWR sky130_fd_sc_hd__fill_1
XFILLER_14_94 VGND VGND VPWR VPWR sky130_fd_sc_hd__fill_1
X_1190_ _1190_/A _1200_/A _1190_/C _1193_/A1 VGND VGND VPWR VPWR _1190_/X sky130_fd_sc_hd__or4b_2
Xinput9 b_in[0] VGND VGND VPWR VPWR input9/X sky130_fd_sc_hd__clkdlybuf4s25_1
X_0974_ _0978_/A _1035_/A _0974_/C _0978_/C VGND VGND VPWR VPWR _0974_/Y sky130_fd_sc_hd__nand4_2
XPHY_EDGE_ROW_40_Left_89 VGND VGND VPWR VPWR sky130_fd_sc_hd__decap_3
XFILLER_19_39 VGND VGND VPWR VPWR sky130_fd_sc_hd__decap_3
XFILLER_27_104 VGND VGND VPWR VPWR sky130_fd_sc_hd__fill_2
XFILLER_35_27 VGND VGND VPWR VPWR sky130_fd_sc_hd__fill_2
XFILLER_35_192 VGND VGND VPWR VPWR sky130_fd_sc_hd__decap_3
XFILLER_2_203 VGND VGND VPWR VPWR sky130_fd_sc_hd__decap_3
XFILLER_18_115 VGND VGND VPWR VPWR sky130_fd_sc_hd__decap_3
XFILLER_18_159 VGND VGND VPWR VPWR sky130_fd_sc_hd__decap_3
XFILLER_26_170 VGND VGND VPWR VPWR sky130_fd_sc_hd__decap_3
XFILLER_33_107 VGND VGND VPWR VPWR sky130_fd_sc_hd__fill_1
XFILLER_41_140 VGND VGND VPWR VPWR sky130_fd_sc_hd__decap_3
XFILLER_41_184 VGND VGND VPWR VPWR sky130_fd_sc_hd__fill_2
XFILLER_41_195 VGND VGND VPWR VPWR sky130_fd_sc_hd__decap_3
XFILLER_41_81 VGND VGND VPWR VPWR sky130_fd_sc_hd__decap_3
X_0690_ _1029_/C VGND VGND VPWR VPWR _0759_/A sky130_fd_sc_hd__inv_2
XFILLER_44_6 VGND VGND VPWR VPWR sky130_fd_sc_hd__decap_3
XFILLER_2_75 VGND VGND VPWR VPWR sky130_fd_sc_hd__decap_3
X_1173_ _1174_/B _1174_/A _1182_/A _1140_/A VGND VGND VPWR VPWR _1173_/X sky130_fd_sc_hd__o211a_2
X_1242_ _1242_/A _1242_/B _1242_/C VGND VGND VPWR VPWR _1242_/X sky130_fd_sc_hd__or3_2
XPHY_EDGE_ROW_10_Right_10 VGND VGND VPWR VPWR sky130_fd_sc_hd__decap_3
XFILLER_17_181 VGND VGND VPWR VPWR sky130_fd_sc_hd__decap_3
XFILLER_32_162 VGND VGND VPWR VPWR sky130_fd_sc_hd__decap_3
XFILLER_32_184 VGND VGND VPWR VPWR sky130_fd_sc_hd__decap_3
XTAP_TAPCELL_ROW_19_198 VGND VPWR sky130_fd_sc_hd__tapvpwrvgnd_1
X_0957_ _1027_/A _1104_/C VGND VGND VPWR VPWR _0977_/A sky130_fd_sc_hd__nand2_2
X_0888_ _0888_/A _0890_/A _0890_/B VGND VGND VPWR VPWR _0888_/Y sky130_fd_sc_hd__nor3_2
XFILLER_15_107 VGND VGND VPWR VPWR sky130_fd_sc_hd__decap_3
XFILLER_46_59 VGND VGND VPWR VPWR sky130_fd_sc_hd__decap_3
XFILLER_46_221 VGND VGND VPWR VPWR sky130_fd_sc_hd__decap_3
XFILLER_46_265 VGND VGND VPWR VPWR sky130_fd_sc_hd__decap_3
XPHY_EDGE_ROW_1_Left_50 VGND VGND VPWR VPWR sky130_fd_sc_hd__decap_3
XFILLER_14_151 VGND VGND VPWR VPWR sky130_fd_sc_hd__decap_3
XFILLER_14_195 VGND VGND VPWR VPWR sky130_fd_sc_hd__fill_1
Xinput12 b_in[3] VGND VGND VPWR VPWR _1293_/D sky130_fd_sc_hd__clkdlybuf4s25_1
X_0811_ split/A _0811_/B _0961_/C _0899_/B VGND VGND VPWR VPWR _0811_/Y sky130_fd_sc_hd__nand4_4
X_0742_ _0816_/A _0742_/B VGND VGND VPWR VPWR _0745_/A sky130_fd_sc_hd__nand2_2
X_0673_ _0663_/A _0663_/B _0663_/C VGND VGND VPWR VPWR _0687_/A sky130_fd_sc_hd__a21boi_4
XFILLER_42_3 VGND VGND VPWR VPWR sky130_fd_sc_hd__decap_3
XFILLER_16_29 VGND VGND VPWR VPWR sky130_fd_sc_hd__decap_3
XFILLER_37_265 VGND VGND VPWR VPWR sky130_fd_sc_hd__decap_3
X_1087_ _1065_/Y _1066_/X _1049_/B VGND VGND VPWR VPWR _1087_/Y sky130_fd_sc_hd__o21ai_2
X_1156_ _1299_/Q _1156_/B VGND VGND VPWR VPWR _1236_/B sky130_fd_sc_hd__nor2_2
X_1225_ _1218_/B _1221_/Y _1224_/Y VGND VGND VPWR VPWR _1225_/X sky130_fd_sc_hd__o21a_2
XFILLER_20_132 VGND VGND VPWR VPWR sky130_fd_sc_hd__fill_1
XFILLER_28_243 VGND VGND VPWR VPWR sky130_fd_sc_hd__decap_3
XPHY_EDGE_ROW_43_Left_92 VGND VGND VPWR VPWR sky130_fd_sc_hd__decap_3
XFILLER_11_110 VGND VGND VPWR VPWR sky130_fd_sc_hd__fill_2
XFILLER_43_246 VGND VGND VPWR VPWR sky130_fd_sc_hd__decap_3
XFILLER_43_279 VGND VGND VPWR VPWR sky130_fd_sc_hd__fill_1
XTAP_TAPCELL_ROW_38_293 VGND VPWR sky130_fd_sc_hd__tapvpwrvgnd_1
XFILLER_11_143 VGND VGND VPWR VPWR sky130_fd_sc_hd__fill_1
XFILLER_19_265 VGND VGND VPWR VPWR sky130_fd_sc_hd__decap_3
XFILLER_34_246 VGND VGND VPWR VPWR sky130_fd_sc_hd__decap_3
X_1010_ _1010_/A _1018_/B _1063_/A _1010_/D VGND VGND VPWR VPWR _1011_/B sky130_fd_sc_hd__nand4_2
XFILLER_8_85 VGND VGND VPWR VPWR sky130_fd_sc_hd__decap_3
XFILLER_8_63 VGND VGND VPWR VPWR sky130_fd_sc_hd__decap_3
XFILLER_8_41 VGND VGND VPWR VPWR sky130_fd_sc_hd__decap_3
X_0725_ _0722_/Y _0768_/A _0724_/X VGND VGND VPWR VPWR _0727_/A sky130_fd_sc_hd__a21o_4
X_0656_ _0653_/X _0652_/B _0652_/A VGND VGND VPWR VPWR _0656_/X sky130_fd_sc_hd__a21bo_4
X_1208_ _1210_/B _1207_/X _1260_/Q wire55/X VGND VGND VPWR VPWR _1260_/D sky130_fd_sc_hd__a2bb2o_2
XFILLER_25_202 VGND VGND VPWR VPWR sky130_fd_sc_hd__decap_3
XFILLER_40_238 VGND VGND VPWR VPWR sky130_fd_sc_hd__decap_3
XFILLER_43_38 VGND VGND VPWR VPWR sky130_fd_sc_hd__decap_3
X_1139_ _1139_/A _1139_/B _1142_/A VGND VGND VPWR VPWR _1140_/B sky130_fd_sc_hd__nand3_2
XFILLER_17_83 VGND VGND VPWR VPWR sky130_fd_sc_hd__decap_3
XFILLER_33_60 VGND VGND VPWR VPWR sky130_fd_sc_hd__fill_1
XTAP_TAPCELL_ROW_1_109 VGND VPWR sky130_fd_sc_hd__tapvpwrvgnd_1
XFILLER_22_227 VGND VGND VPWR VPWR sky130_fd_sc_hd__decap_3
XPHY_EDGE_ROW_8_Right_8 VGND VGND VPWR VPWR sky130_fd_sc_hd__decap_3
XFILLER_30_271 VGND VGND VPWR VPWR sky130_fd_sc_hd__decap_3
XTAP_TAPCELL_ROW_32_266 VGND VPWR sky130_fd_sc_hd__tapvpwrvgnd_1
X_0708_ split/X _0713_/A _0820_/A _0894_/B _0707_/Y VGND VGND VPWR VPWR _0712_/B sky130_fd_sc_hd__a41oi_4
X_0639_ _1283_/Q VGND VGND VPWR VPWR _0689_/A sky130_fd_sc_hd__buf_1
XPHY_EDGE_ROW_39_Right_39 VGND VGND VPWR VPWR sky130_fd_sc_hd__decap_3
XTAP_TAPCELL_ROW_23_222 VGND VPWR sky130_fd_sc_hd__tapvpwrvgnd_1
XPHY_EDGE_ROW_48_Right_48 VGND VGND VPWR VPWR sky130_fd_sc_hd__decap_3
XFILLER_9_209 VGND VGND VPWR VPWR sky130_fd_sc_hd__decap_3
XFILLER_48_102 VGND VGND VPWR VPWR sky130_fd_sc_hd__fill_2
XFILLER_48_113 VGND VGND VPWR VPWR sky130_fd_sc_hd__decap_3
XTAP_TAPCELL_ROW_46_336 VGND VPWR sky130_fd_sc_hd__tapvpwrvgnd_1
XFILLER_44_81 VGND VGND VPWR VPWR sky130_fd_sc_hd__decap_3
X_0990_ _0990_/A _0990_/B VGND VGND VPWR VPWR _0991_/B sky130_fd_sc_hd__nand2_2
XFILLER_8_253 VGND VGND VPWR VPWR sky130_fd_sc_hd__decap_3
XFILLER_5_64 VGND VGND VPWR VPWR sky130_fd_sc_hd__decap_3
XFILLER_5_31 VGND VGND VPWR VPWR sky130_fd_sc_hd__decap_3
XFILLER_39_124 VGND VGND VPWR VPWR sky130_fd_sc_hd__decap_3
XFILLER_47_190 VGND VGND VPWR VPWR sky130_fd_sc_hd__decap_3
XFILLER_24_18 VGND VGND VPWR VPWR sky130_fd_sc_hd__decap_3
XFILLER_24_29 VGND VGND VPWR VPWR sky130_fd_sc_hd__decap_3
XTAP_TAPCELL_ROW_20_203 VGND VPWR sky130_fd_sc_hd__tapvpwrvgnd_1
XFILLER_6_9 VGND VGND VPWR VPWR sky130_fd_sc_hd__decap_3
XFILLER_45_149 VGND VGND VPWR VPWR sky130_fd_sc_hd__decap_3
XFILLER_30_72 VGND VGND VPWR VPWR sky130_fd_sc_hd__decap_3
XFILLER_39_9 VGND VGND VPWR VPWR sky130_fd_sc_hd__decap_3
XFILLER_36_105 VGND VGND VPWR VPWR sky130_fd_sc_hd__decap_3
XFILLER_36_116 VGND VGND VPWR VPWR sky130_fd_sc_hd__decap_3
XFILLER_36_138 VGND VGND VPWR VPWR sky130_fd_sc_hd__fill_2
X_0973_ _0973_/A _0973_/B VGND VGND VPWR VPWR _0978_/C sky130_fd_sc_hd__nand2_2
XFILLER_19_18 VGND VGND VPWR VPWR sky130_fd_sc_hd__decap_3
XFILLER_4_6 VGND VGND VPWR VPWR sky130_fd_sc_hd__decap_3
XFILLER_18_127 VGND VGND VPWR VPWR sky130_fd_sc_hd__decap_3
XFILLER_25_72 VGND VGND VPWR VPWR sky130_fd_sc_hd__decap_3
XFILLER_25_94 VGND VGND VPWR VPWR sky130_fd_sc_hd__decap_3
XFILLER_41_163 VGND VGND VPWR VPWR sky130_fd_sc_hd__decap_3
Xrebuffer90 _1059_/C VGND VGND VPWR VPWR _1094_/C sky130_fd_sc_hd__buf_2
XFILLER_1_281 VGND VGND VPWR VPWR sky130_fd_sc_hd__decap_3
XFILLER_37_6 VGND VGND VPWR VPWR sky130_fd_sc_hd__decap_3
X_1241_ _1239_/Y _1240_/X _1300_/Q _1183_/A VGND VGND VPWR VPWR _1300_/D sky130_fd_sc_hd__a2bb2o_2
X_1172_ _1305_/Q _1273_/Q _1171_/Y VGND VGND VPWR VPWR _1174_/A sky130_fd_sc_hd__o21a_2
XFILLER_17_193 VGND VGND VPWR VPWR sky130_fd_sc_hd__fill_1
XFILLER_32_141 VGND VGND VPWR VPWR sky130_fd_sc_hd__decap_3
X_0956_ _0947_/A _0947_/B _0947_/C VGND VGND VPWR VPWR _0956_/Y sky130_fd_sc_hd__a21oi_2
XTAP_TAPCELL_ROW_19_199 VGND VPWR sky130_fd_sc_hd__tapvpwrvgnd_1
X_0887_ _0958_/A _0961_/C VGND VGND VPWR VPWR _0890_/B sky130_fd_sc_hd__nand2_2
XFILLER_46_27 VGND VGND VPWR VPWR sky130_fd_sc_hd__fill_1
XFILLER_15_119 VGND VGND VPWR VPWR sky130_fd_sc_hd__decap_3
XFILLER_23_152 VGND VGND VPWR VPWR sky130_fd_sc_hd__decap_3
XFILLER_11_41 VGND VGND VPWR VPWR sky130_fd_sc_hd__decap_3
XFILLER_23_196 VGND VGND VPWR VPWR sky130_fd_sc_hd__decap_3
XFILLER_11_63 VGND VGND VPWR VPWR sky130_fd_sc_hd__decap_3
XFILLER_36_71 VGND VGND VPWR VPWR sky130_fd_sc_hd__decap_3
XFILLER_46_200 VGND VGND VPWR VPWR sky130_fd_sc_hd__decap_3
XFILLER_46_233 VGND VGND VPWR VPWR sky130_fd_sc_hd__decap_3
XFILLER_46_277 VGND VGND VPWR VPWR sky130_fd_sc_hd__fill_1
XFILLER_14_141 VGND VGND VPWR VPWR sky130_fd_sc_hd__fill_1
Xinput13 b_in[4] VGND VGND VPWR VPWR _1294_/D sky130_fd_sc_hd__clkdlybuf4s25_1
X_0810_ _0810_/A _0810_/B VGND VGND VPWR VPWR _0810_/Y sky130_fd_sc_hd__nand2_4
X_0741_ _0814_/A _1044_/A VGND VGND VPWR VPWR _0755_/A sky130_fd_sc_hd__nand2_2
X_0672_ _0656_/X _0668_/A _0668_/B VGND VGND VPWR VPWR _0672_/X sky130_fd_sc_hd__o21ba_2
XFILLER_35_3 VGND VGND VPWR VPWR sky130_fd_sc_hd__decap_3
X_1224_ _1224_/A _1224_/B VGND VGND VPWR VPWR _1224_/Y sky130_fd_sc_hd__nor2_2
XFILLER_37_277 VGND VGND VPWR VPWR sky130_fd_sc_hd__decap_3
X_1086_ _1065_/Y _1066_/X _1085_/Y _1049_/B VGND VGND VPWR VPWR _1090_/A sky130_fd_sc_hd__o211ai_2
X_1155_ _1298_/Q _1266_/Q VGND VGND VPWR VPWR _1236_/A sky130_fd_sc_hd__nand2_2
XFILLER_20_100 VGND VGND VPWR VPWR sky130_fd_sc_hd__decap_3
XFILLER_20_155 VGND VGND VPWR VPWR sky130_fd_sc_hd__decap_3
XFILLER_32_29 VGND VGND VPWR VPWR sky130_fd_sc_hd__decap_3
X_0939_ _0873_/A _0873_/B _0873_/C _0879_/C VGND VGND VPWR VPWR _0939_/X sky130_fd_sc_hd__o31a_2
XTAP_TAPCELL_ROW_15_180 VGND VPWR sky130_fd_sc_hd__tapvpwrvgnd_1
XFILLER_28_200 VGND VGND VPWR VPWR sky130_fd_sc_hd__decap_3
XFILLER_43_225 VGND VGND VPWR VPWR sky130_fd_sc_hd__decap_3
XFILLER_43_258 VGND VGND VPWR VPWR sky130_fd_sc_hd__decap_3
XTAP_TAPCELL_ROW_38_294 VGND VPWR sky130_fd_sc_hd__tapvpwrvgnd_1
XFILLER_7_137 VGND VGND VPWR VPWR sky130_fd_sc_hd__decap_3
XFILLER_19_211 VGND VGND VPWR VPWR sky130_fd_sc_hd__fill_2
XFILLER_19_222 VGND VGND VPWR VPWR sky130_fd_sc_hd__fill_2
XFILLER_19_277 VGND VGND VPWR VPWR sky130_fd_sc_hd__decap_3
XFILLER_34_203 VGND VGND VPWR VPWR sky130_fd_sc_hd__decap_3
XFILLER_47_81 VGND VGND VPWR VPWR sky130_fd_sc_hd__decap_3
XTAP_TAPCELL_ROW_29_250 VGND VPWR sky130_fd_sc_hd__tapvpwrvgnd_1
XFILLER_42_280 VGND VGND VPWR VPWR sky130_fd_sc_hd__decap_3
XFILLER_8_97 VGND VGND VPWR VPWR sky130_fd_sc_hd__decap_3
XFILLER_8_75 VGND VGND VPWR VPWR sky130_fd_sc_hd__decap_3
X_0724_ _0683_/A _0683_/C _0683_/B _0723_/Y VGND VGND VPWR VPWR _0724_/X sky130_fd_sc_hd__a31o_2
X_0655_ _0643_/C _0652_/Y _0654_/X VGND VGND VPWR VPWR _1268_/D sky130_fd_sc_hd__a21oi_2
X_1207_ _1207_/A1 _1205_/X _1202_/Y _0799_/A _1191_/B VGND VGND VPWR VPWR _1207_/X
+ sky130_fd_sc_hd__a311o_2
X_1138_ _1139_/A _1142_/A _1139_/B VGND VGND VPWR VPWR _1141_/A sky130_fd_sc_hd__a21oi_2
X_1069_ _1023_/Y _0964_/Y _1029_/A VGND VGND VPWR VPWR _1071_/B sky130_fd_sc_hd__a21o_2
XFILLER_16_214 VGND VGND VPWR VPWR sky130_fd_sc_hd__decap_3
XFILLER_17_40 VGND VGND VPWR VPWR sky130_fd_sc_hd__decap_3
XFILLER_17_95 VGND VGND VPWR VPWR sky130_fd_sc_hd__decap_3
XFILLER_31_228 VGND VGND VPWR VPWR sky130_fd_sc_hd__decap_3
XFILLER_3_173 VGND VGND VPWR VPWR sky130_fd_sc_hd__decap_3
XFILLER_22_206 VGND VGND VPWR VPWR sky130_fd_sc_hd__decap_3
XFILLER_22_239 VGND VGND VPWR VPWR sky130_fd_sc_hd__decap_3
XFILLER_30_283 VGND VGND VPWR VPWR sky130_fd_sc_hd__decap_3
X_0707_ _0958_/A _1285_/Q VGND VGND VPWR VPWR _0707_/Y sky130_fd_sc_hd__nand2_2
XTAP_TAPCELL_ROW_32_267 VGND VPWR sky130_fd_sc_hd__tapvpwrvgnd_1
X_0638_ split/A VGND VGND VPWR VPWR _1023_/A sky130_fd_sc_hd__buf_6
XFILLER_21_261 VGND VGND VPWR VPWR sky130_fd_sc_hd__decap_3
XFILLER_48_147 VGND VGND VPWR VPWR sky130_fd_sc_hd__decap_3
XFILLER_48_169 VGND VGND VPWR VPWR sky130_fd_sc_hd__decap_3
XFILLER_28_94 VGND VGND VPWR VPWR sky130_fd_sc_hd__decap_3
XTAP_TAPCELL_ROW_46_337 VGND VPWR sky130_fd_sc_hd__tapvpwrvgnd_1
XFILLER_5_76 VGND VGND VPWR VPWR sky130_fd_sc_hd__decap_3
XFILLER_39_136 VGND VGND VPWR VPWR sky130_fd_sc_hd__decap_3
XTAP_TAPCELL_ROW_20_204 VGND VPWR sky130_fd_sc_hd__tapvpwrvgnd_1
XFILLER_38_191 VGND VGND VPWR VPWR sky130_fd_sc_hd__fill_1
XTAP_TAPCELL_ROW_43_318 VGND VPWR sky130_fd_sc_hd__tapvpwrvgnd_1
XFILLER_14_74 VGND VGND VPWR VPWR sky130_fd_sc_hd__decap_3
XFILLER_14_85 VGND VGND VPWR VPWR sky130_fd_sc_hd__decap_3
XFILLER_5_235 VGND VGND VPWR VPWR sky130_fd_sc_hd__decap_3
XFILLER_5_202 VGND VGND VPWR VPWR sky130_fd_sc_hd__fill_1
XFILLER_5_279 VGND VGND VPWR VPWR sky130_fd_sc_hd__fill_1
X_0972_ _0973_/B _0905_/Y _0973_/A _0971_/Y VGND VGND VPWR VPWR _0972_/Y sky130_fd_sc_hd__o211ai_2
XFILLER_27_117 VGND VGND VPWR VPWR sky130_fd_sc_hd__fill_2
XFILLER_35_18 VGND VGND VPWR VPWR sky130_fd_sc_hd__decap_3
XFILLER_35_183 VGND VGND VPWR VPWR sky130_fd_sc_hd__decap_3
XFILLER_18_139 VGND VGND VPWR VPWR sky130_fd_sc_hd__fill_1
XFILLER_26_161 VGND VGND VPWR VPWR sky130_fd_sc_hd__decap_3
XFILLER_41_175 VGND VGND VPWR VPWR sky130_fd_sc_hd__decap_3
Xrebuffer91 _0819_/B VGND VGND VPWR VPWR _0917_/A2 sky130_fd_sc_hd__buf_2
Xrebuffer80 _0978_/B VGND VGND VPWR VPWR _0974_/C sky130_fd_sc_hd__buf_2
X_1171_ _1150_/X _1171_/B _1171_/C VGND VGND VPWR VPWR _1171_/Y sky130_fd_sc_hd__nand3b_4
X_1240_ _1160_/Y _1240_/A2 _1159_/X _1191_/A _1191_/B VGND VGND VPWR VPWR _1240_/X
+ sky130_fd_sc_hd__a311o_2
XFILLER_32_120 VGND VGND VPWR VPWR sky130_fd_sc_hd__fill_2
XFILLER_32_197 VGND VGND VPWR VPWR sky130_fd_sc_hd__decap_3
X_0955_ _1058_/B _1058_/A _0871_/X _0875_/X VGND VGND VPWR VPWR _0955_/X sky130_fd_sc_hd__o2bb2a_2
X_0886_ _0854_/A _0854_/B _0886_/B1 VGND VGND VPWR VPWR _0886_/Y sky130_fd_sc_hd__a21oi_2
XFILLER_23_164 VGND VGND VPWR VPWR sky130_fd_sc_hd__decap_3
XFILLER_23_175 VGND VGND VPWR VPWR sky130_fd_sc_hd__decap_3
XFILLER_36_50 VGND VGND VPWR VPWR sky130_fd_sc_hd__decap_3
XFILLER_36_83 VGND VGND VPWR VPWR sky130_fd_sc_hd__fill_1
XFILLER_46_212 VGND VGND VPWR VPWR sky130_fd_sc_hd__decap_3
XFILLER_46_245 VGND VGND VPWR VPWR sky130_fd_sc_hd__decap_3
XFILLER_46_256 VGND VGND VPWR VPWR sky130_fd_sc_hd__decap_3
XFILLER_14_197 VGND VGND VPWR VPWR sky130_fd_sc_hd__decap_3
Xinput14 b_in[5] VGND VGND VPWR VPWR _1295_/D sky130_fd_sc_hd__clkdlybuf4s25_1
X_0740_ _0801_/A _0801_/B VGND VGND VPWR VPWR _0740_/X sky130_fd_sc_hd__and2_2
X_0671_ _0656_/X _0668_/Y _0670_/Y VGND VGND VPWR VPWR _1269_/D sky130_fd_sc_hd__o21a_2
XFILLER_37_234 VGND VGND VPWR VPWR sky130_fd_sc_hd__decap_3
XFILLER_37_256 VGND VGND VPWR VPWR sky130_fd_sc_hd__decap_3
X_1154_ _1301_/Q _1269_/Q VGND VGND VPWR VPWR _1242_/B sky130_fd_sc_hd__nor2_2
X_1223_ _1263_/Q _1281_/Q VGND VGND VPWR VPWR _1224_/B sky130_fd_sc_hd__and2_2
XFILLER_20_123 VGND VGND VPWR VPWR sky130_fd_sc_hd__decap_3
X_1085_ _1085_/A _1085_/B VGND VGND VPWR VPWR _1085_/Y sky130_fd_sc_hd__nor2_2
X_0938_ _0947_/A _0947_/B _0947_/C VGND VGND VPWR VPWR _0938_/X sky130_fd_sc_hd__and3_4
X_0869_ _1297_/Q VGND VGND VPWR VPWR _1001_/D sky130_fd_sc_hd__clkbuf_1
XTAP_TAPCELL_ROW_15_181 VGND VPWR sky130_fd_sc_hd__tapvpwrvgnd_1
XTAP_TAPCELL_ROW_7_138 VGND VPWR sky130_fd_sc_hd__tapvpwrvgnd_1
XFILLER_28_212 VGND VGND VPWR VPWR sky130_fd_sc_hd__decap_3
XFILLER_43_237 VGND VGND VPWR VPWR sky130_fd_sc_hd__decap_3
XTAP_TAPCELL_ROW_38_295 VGND VPWR sky130_fd_sc_hd__tapvpwrvgnd_1
XFILLER_11_178 VGND VGND VPWR VPWR sky130_fd_sc_hd__decap_3
XFILLER_7_105 VGND VGND VPWR VPWR sky130_fd_sc_hd__fill_1
XFILLER_22_85 VGND VGND VPWR VPWR sky130_fd_sc_hd__decap_3
XFILLER_19_201 VGND VGND VPWR VPWR sky130_fd_sc_hd__fill_1
XFILLER_19_256 VGND VGND VPWR VPWR sky130_fd_sc_hd__decap_3
XFILLER_47_60 VGND VGND VPWR VPWR sky130_fd_sc_hd__decap_3
XTAP_TAPCELL_ROW_29_251 VGND VPWR sky130_fd_sc_hd__tapvpwrvgnd_1
X_0723_ _0704_/A _0676_/Y _1081_/C _0723_/B1 VGND VGND VPWR VPWR _0723_/Y sky130_fd_sc_hd__a31oi_2
XFILLER_8_32 VGND VGND VPWR VPWR sky130_fd_sc_hd__decap_3
X_0654_ _0652_/A _0652_/B _0653_/X _1191_/A VGND VGND VPWR VPWR _0654_/X sky130_fd_sc_hd__a31o_2
XFILLER_6_193 VGND VGND VPWR VPWR sky130_fd_sc_hd__decap_3
X_1137_ _1137_/A _1137_/B VGND VGND VPWR VPWR _1139_/B sky130_fd_sc_hd__nand2_2
X_1206_ _1202_/Y _1200_/Y _1205_/X VGND VGND VPWR VPWR _1206_/Y sky130_fd_sc_hd__a21oi_4
XFILLER_33_270 VGND VGND VPWR VPWR sky130_fd_sc_hd__decap_3
XFILLER_33_281 VGND VGND VPWR VPWR sky130_fd_sc_hd__decap_3
XFILLER_43_18 VGND VGND VPWR VPWR sky130_fd_sc_hd__decap_3
X_1068_ _1068_/A _1068_/B VGND VGND VPWR VPWR _1120_/A sky130_fd_sc_hd__nand2_2
XFILLER_16_226 VGND VGND VPWR VPWR sky130_fd_sc_hd__decap_3
XFILLER_16_259 VGND VGND VPWR VPWR sky130_fd_sc_hd__decap_3
XFILLER_17_52 VGND VGND VPWR VPWR sky130_fd_sc_hd__decap_3
XFILLER_17_63 VGND VGND VPWR VPWR sky130_fd_sc_hd__decap_3
XFILLER_24_281 VGND VGND VPWR VPWR sky130_fd_sc_hd__decap_3
XFILLER_33_95 VGND VGND VPWR VPWR sky130_fd_sc_hd__decap_3
XFILLER_12_6 VGND VGND VPWR VPWR sky130_fd_sc_hd__decap_3
XFILLER_15_281 VGND VGND VPWR VPWR sky130_fd_sc_hd__decap_3
XFILLER_22_218 VGND VGND VPWR VPWR sky130_fd_sc_hd__decap_3
XFILLER_30_251 VGND VGND VPWR VPWR sky130_fd_sc_hd__fill_1
X_0706_ _1287_/Q VGND VGND VPWR VPWR _0894_/B sky130_fd_sc_hd__buf_6
XFILLER_38_29 VGND VGND VPWR VPWR sky130_fd_sc_hd__fill_2
X_0637_ _0816_/A VGND VGND VPWR VPWR split/A sky130_fd_sc_hd__buf_12
XTAP_TAPCELL_ROW_0_100 VGND VPWR sky130_fd_sc_hd__tapvpwrvgnd_1
XFILLER_21_240 VGND VGND VPWR VPWR sky130_fd_sc_hd__decap_3
XFILLER_21_284 VGND VGND VPWR VPWR sky130_fd_sc_hd__fill_2
XFILLER_0_111 VGND VGND VPWR VPWR sky130_fd_sc_hd__fill_1
XFILLER_44_72 VGND VGND VPWR VPWR sky130_fd_sc_hd__decap_3
XFILLER_8_200 VGND VGND VPWR VPWR sky130_fd_sc_hd__decap_3
XFILLER_12_284 VGND VGND VPWR VPWR sky130_fd_sc_hd__fill_2
XFILLER_5_55 VGND VGND VPWR VPWR sky130_fd_sc_hd__fill_1
XFILLER_5_44 VGND VGND VPWR VPWR sky130_fd_sc_hd__decap_3
XFILLER_10_3 VGND VGND VPWR VPWR sky130_fd_sc_hd__decap_3
XFILLER_5_99 VGND VGND VPWR VPWR sky130_fd_sc_hd__fill_1
XFILLER_47_181 VGND VGND VPWR VPWR sky130_fd_sc_hd__decap_3
XTAP_TAPCELL_ROW_20_205 VGND VPWR sky130_fd_sc_hd__tapvpwrvgnd_1
XPHY_EDGE_ROW_17_Left_66 VGND VGND VPWR VPWR sky130_fd_sc_hd__decap_3
XTAP_TAPCELL_ROW_43_319 VGND VPWR sky130_fd_sc_hd__tapvpwrvgnd_1
XFILLER_14_64 VGND VGND VPWR VPWR sky130_fd_sc_hd__fill_1
XFILLER_30_85 VGND VGND VPWR VPWR sky130_fd_sc_hd__decap_3
XFILLER_29_192 VGND VGND VPWR VPWR sky130_fd_sc_hd__decap_3
XFILLER_44_151 VGND VGND VPWR VPWR sky130_fd_sc_hd__decap_3
X_0971_ _1035_/A _0978_/B VGND VGND VPWR VPWR _0971_/Y sky130_fd_sc_hd__nand2_2
XFILLER_35_195 VGND VGND VPWR VPWR sky130_fd_sc_hd__decap_3
XFILLER_2_206 VGND VGND VPWR VPWR sky130_fd_sc_hd__fill_1
XFILLER_2_228 VGND VGND VPWR VPWR sky130_fd_sc_hd__decap_3
XFILLER_18_118 VGND VGND VPWR VPWR sky130_fd_sc_hd__decap_3
Xrebuffer81 _0844_/A VGND VGND VPWR VPWR _0886_/B1 sky130_fd_sc_hd__buf_2
XFILLER_26_195 VGND VGND VPWR VPWR sky130_fd_sc_hd__fill_1
XFILLER_41_143 VGND VGND VPWR VPWR sky130_fd_sc_hd__fill_1
XFILLER_41_198 VGND VGND VPWR VPWR sky130_fd_sc_hd__decap_3
Xrebuffer92 _0742_/B VGND VGND VPWR VPWR output23/A sky130_fd_sc_hd__buf_2
XFILLER_41_84 VGND VGND VPWR VPWR sky130_fd_sc_hd__decap_3
XFILLER_44_9 VGND VGND VPWR VPWR sky130_fd_sc_hd__decap_3
Xrebuffer160 _1206_/Y VGND VGND VPWR VPWR _1210_/B sky130_fd_sc_hd__buf_4
XFILLER_2_67 VGND VGND VPWR VPWR sky130_fd_sc_hd__decap_3
XFILLER_2_78 VGND VGND VPWR VPWR sky130_fd_sc_hd__decap_3
X_1170_ _1250_/C _1250_/B _1250_/A VGND VGND VPWR VPWR _1171_/B sky130_fd_sc_hd__o21ai_4
XFILLER_17_184 VGND VGND VPWR VPWR sky130_fd_sc_hd__decap_3
XFILLER_32_165 VGND VGND VPWR VPWR sky130_fd_sc_hd__fill_2
XFILLER_32_187 VGND VGND VPWR VPWR sky130_fd_sc_hd__decap_3
X_0954_ _0951_/Y _0952_/Y _0953_/Y VGND VGND VPWR VPWR _1274_/D sky130_fd_sc_hd__o21a_2
X_0885_ _0885_/A _0885_/B _0885_/C VGND VGND VPWR VPWR _0885_/X sky130_fd_sc_hd__and3_2
X_1299_ clkload4/A _1299_/D wire65/X VGND VGND VPWR VPWR _1299_/Q sky130_fd_sc_hd__dfrtp_2
XFILLER_23_187 VGND VGND VPWR VPWR sky130_fd_sc_hd__decap_3
XFILLER_11_32 VGND VGND VPWR VPWR sky130_fd_sc_hd__decap_3
XFILLER_46_224 VGND VGND VPWR VPWR sky130_fd_sc_hd__decap_3
XFILLER_14_132 VGND VGND VPWR VPWR sky130_fd_sc_hd__decap_3
XFILLER_14_154 VGND VGND VPWR VPWR sky130_fd_sc_hd__decap_3
XFILLER_36_62 VGND VGND VPWR VPWR sky130_fd_sc_hd__decap_3
XFILLER_46_268 VGND VGND VPWR VPWR sky130_fd_sc_hd__decap_3
Xinput15 b_in[6] VGND VGND VPWR VPWR _1296_/D sky130_fd_sc_hd__clkdlybuf4s25_1
X_0670_ _0656_/X _0668_/Y _1117_/A VGND VGND VPWR VPWR _0670_/Y sky130_fd_sc_hd__a21oi_2
XFILLER_42_6 VGND VGND VPWR VPWR sky130_fd_sc_hd__decap_3
XFILLER_37_268 VGND VGND VPWR VPWR sky130_fd_sc_hd__decap_3
X_1084_ _1083_/C _1083_/B _1083_/D _1083_/A VGND VGND VPWR VPWR _1085_/B sky130_fd_sc_hd__a22oi_2
X_1153_ _1302_/Q _1270_/Q VGND VGND VPWR VPWR _1247_/B sky130_fd_sc_hd__nand2_2
X_1222_ _1263_/Q _1281_/Q VGND VGND VPWR VPWR _1224_/A sky130_fd_sc_hd__nor2_2
XTAP_TAPCELL_ROW_15_182 VGND VPWR sky130_fd_sc_hd__tapvpwrvgnd_1
X_0937_ _0940_/A _1001_/D VGND VGND VPWR VPWR _0947_/C sky130_fd_sc_hd__and2_2
X_0868_ _0790_/Y _0792_/Y _0787_/Y _0867_/X VGND VGND VPWR VPWR _0868_/X sky130_fd_sc_hd__o22a_2
X_0799_ _0799_/A _0799_/B VGND VGND VPWR VPWR _0799_/Y sky130_fd_sc_hd__nor2_2
XTAP_TAPCELL_ROW_7_139 VGND VPWR sky130_fd_sc_hd__tapvpwrvgnd_1
XFILLER_28_246 VGND VGND VPWR VPWR sky130_fd_sc_hd__decap_3
XFILLER_43_249 VGND VGND VPWR VPWR sky130_fd_sc_hd__decap_3
Xwire72 wire72/A VGND VGND VPWR VPWR wire72/X sky130_fd_sc_hd__clkbuf_4
XTAP_TAPCELL_ROW_38_296 VGND VPWR sky130_fd_sc_hd__tapvpwrvgnd_1
XFILLER_11_102 VGND VGND VPWR VPWR sky130_fd_sc_hd__fill_1
XFILLER_11_113 VGND VGND VPWR VPWR sky130_fd_sc_hd__decap_3
XFILLER_22_42 VGND VGND VPWR VPWR sky130_fd_sc_hd__decap_3
XPHY_EDGE_ROW_5_Left_54 VGND VGND VPWR VPWR sky130_fd_sc_hd__decap_3
XFILLER_19_268 VGND VGND VPWR VPWR sky130_fd_sc_hd__decap_3
XFILLER_47_50 VGND VGND VPWR VPWR sky130_fd_sc_hd__decap_3
XFILLER_47_72 VGND VGND VPWR VPWR sky130_fd_sc_hd__decap_3
XTAP_TAPCELL_ROW_29_252 VGND VPWR sky130_fd_sc_hd__tapvpwrvgnd_1
XFILLER_34_249 VGND VGND VPWR VPWR sky130_fd_sc_hd__decap_3
XFILLER_42_271 VGND VGND VPWR VPWR sky130_fd_sc_hd__decap_3
Xclkbuf_3_4__f_clk clkbuf_0_clk/X VGND VGND VPWR VPWR _1291_/CLK sky130_fd_sc_hd__clkbuf_16
XFILLER_8_11 VGND VGND VPWR VPWR sky130_fd_sc_hd__decap_3
X_0722_ _0846_/A _0759_/A _0716_/Y _0720_/X _0721_/Y VGND VGND VPWR VPWR _0722_/Y
+ sky130_fd_sc_hd__o221ai_4
X_0653_ _0704_/A _1282_/Q _1023_/A _0689_/A VGND VGND VPWR VPWR _0653_/X sky130_fd_sc_hd__and4_2
XTAP_TAPCELL_ROW_12_163 VGND VPWR sky130_fd_sc_hd__tapvpwrvgnd_1
XFILLER_8_88 VGND VGND VPWR VPWR sky130_fd_sc_hd__decap_3
XFILLER_8_66 VGND VGND VPWR VPWR sky130_fd_sc_hd__decap_3
XFILLER_8_44 VGND VGND VPWR VPWR sky130_fd_sc_hd__decap_3
XFILLER_6_150 VGND VGND VPWR VPWR sky130_fd_sc_hd__decap_3
XFILLER_25_205 VGND VGND VPWR VPWR sky130_fd_sc_hd__fill_2
X_1136_ _1103_/B _1120_/B _1119_/A _1119_/C _1119_/D VGND VGND VPWR VPWR _1137_/B
+ sky130_fd_sc_hd__a32o_2
X_1205_ _1210_/A _1205_/B VGND VGND VPWR VPWR _1205_/X sky130_fd_sc_hd__or2_2
X_1067_ _1067_/A _1119_/D VGND VGND VPWR VPWR _1068_/B sky130_fd_sc_hd__nand2_2
XPHY_EDGE_ROW_47_Left_96 VGND VGND VPWR VPWR sky130_fd_sc_hd__decap_3
XFILLER_16_205 VGND VGND VPWR VPWR sky130_fd_sc_hd__decap_3
XFILLER_17_31 VGND VGND VPWR VPWR sky130_fd_sc_hd__decap_3
XTAP_TAPCELL_ROW_3_120 VGND VPWR sky130_fd_sc_hd__tapvpwrvgnd_1
XFILLER_17_86 VGND VGND VPWR VPWR sky130_fd_sc_hd__decap_3
XFILLER_33_52 VGND VGND VPWR VPWR sky130_fd_sc_hd__decap_3
XTAP_TAPCELL_ROW_26_233 VGND VPWR sky130_fd_sc_hd__tapvpwrvgnd_1
XFILLER_3_142 VGND VGND VPWR VPWR sky130_fd_sc_hd__fill_1
XFILLER_30_230 VGND VGND VPWR VPWR sky130_fd_sc_hd__decap_3
XFILLER_30_274 VGND VGND VPWR VPWR sky130_fd_sc_hd__decap_3
X_0705_ _1023_/A _0820_/A VGND VGND VPWR VPWR _0705_/X sky130_fd_sc_hd__and2_2
X_0636_ _1291_/Q VGND VGND VPWR VPWR _0816_/A sky130_fd_sc_hd__buf_8
XTAP_TAPCELL_ROW_0_101 VGND VPWR sky130_fd_sc_hd__tapvpwrvgnd_1
X_1119_ _1119_/A _1120_/B _1119_/C _1119_/D VGND VGND VPWR VPWR _1123_/C sky130_fd_sc_hd__nand4_2
XFILLER_21_252 VGND VGND VPWR VPWR sky130_fd_sc_hd__fill_1
XPHY_EDGE_ROW_17_Right_17 VGND VGND VPWR VPWR sky130_fd_sc_hd__decap_3
XFILLER_0_123 VGND VGND VPWR VPWR sky130_fd_sc_hd__decap_3
XFILLER_48_116 VGND VGND VPWR VPWR sky130_fd_sc_hd__decap_3
XPHY_EDGE_ROW_26_Right_26 VGND VGND VPWR VPWR sky130_fd_sc_hd__decap_3
XFILLER_0_189 VGND VGND VPWR VPWR sky130_fd_sc_hd__decap_3
XFILLER_28_74 VGND VGND VPWR VPWR sky130_fd_sc_hd__decap_3
XFILLER_12_230 VGND VGND VPWR VPWR sky130_fd_sc_hd__decap_3
XFILLER_44_51 VGND VGND VPWR VPWR sky130_fd_sc_hd__decap_3
XPHY_EDGE_ROW_35_Right_35 VGND VGND VPWR VPWR sky130_fd_sc_hd__decap_3
XFILLER_8_212 VGND VGND VPWR VPWR sky130_fd_sc_hd__fill_1
XFILLER_8_256 VGND VGND VPWR VPWR sky130_fd_sc_hd__decap_3
XFILLER_5_67 VGND VGND VPWR VPWR sky130_fd_sc_hd__decap_3
XFILLER_5_34 VGND VGND VPWR VPWR sky130_fd_sc_hd__decap_3
XFILLER_39_105 VGND VGND VPWR VPWR sky130_fd_sc_hd__decap_3
XFILLER_39_127 VGND VGND VPWR VPWR sky130_fd_sc_hd__decap_3
XPHY_EDGE_ROW_44_Right_44 VGND VGND VPWR VPWR sky130_fd_sc_hd__decap_3
XFILLER_47_193 VGND VGND VPWR VPWR sky130_fd_sc_hd__decap_3
XTAP_TAPCELL_ROW_20_206 VGND VPWR sky130_fd_sc_hd__tapvpwrvgnd_1
XFILLER_14_32 VGND VGND VPWR VPWR sky130_fd_sc_hd__decap_3
XFILLER_30_64 VGND VGND VPWR VPWR sky130_fd_sc_hd__fill_1
XFILLER_30_75 VGND VGND VPWR VPWR sky130_fd_sc_hd__decap_3
XPHY_EDGE_ROW_34_Left_83 VGND VGND VPWR VPWR sky130_fd_sc_hd__decap_3
XFILLER_36_119 VGND VGND VPWR VPWR sky130_fd_sc_hd__decap_3
X_0970_ _0970_/A _0970_/B _1067_/A _1104_/C VGND VGND VPWR VPWR _0978_/B sky130_fd_sc_hd__nand4_4
XFILLER_35_174 VGND VGND VPWR VPWR sky130_fd_sc_hd__decap_3
XFILLER_4_9 VGND VGND VPWR VPWR sky130_fd_sc_hd__decap_3
XFILLER_41_111 VGND VGND VPWR VPWR sky130_fd_sc_hd__fill_1
Xrebuffer93 _1287_/Q VGND VGND VPWR VPWR _0742_/B sky130_fd_sc_hd__buf_4
Xrebuffer82 _0921_/B VGND VGND VPWR VPWR _0991_/A sky130_fd_sc_hd__buf_2
XFILLER_25_75 VGND VGND VPWR VPWR sky130_fd_sc_hd__decap_3
XFILLER_25_97 VGND VGND VPWR VPWR sky130_fd_sc_hd__fill_1
XFILLER_41_166 VGND VGND VPWR VPWR sky130_fd_sc_hd__fill_2
XFILLER_37_9 VGND VGND VPWR VPWR sky130_fd_sc_hd__decap_3
XFILLER_41_96 VGND VGND VPWR VPWR sky130_fd_sc_hd__fill_1
Xrebuffer161 _1200_/Y VGND VGND VPWR VPWR _1207_/A1 sky130_fd_sc_hd__buf_2
XFILLER_1_262 VGND VGND VPWR VPWR sky130_fd_sc_hd__fill_2
XFILLER_1_284 VGND VGND VPWR VPWR sky130_fd_sc_hd__fill_2
XFILLER_2_24 VGND VGND VPWR VPWR sky130_fd_sc_hd__decap_3
XFILLER_32_100 VGND VGND VPWR VPWR sky130_fd_sc_hd__decap_3
XFILLER_32_144 VGND VGND VPWR VPWR sky130_fd_sc_hd__fill_2
X_0953_ _0952_/Y _0951_/Y _1117_/A VGND VGND VPWR VPWR _0953_/Y sky130_fd_sc_hd__a21oi_2
X_0884_ _1002_/A _0930_/B VGND VGND VPWR VPWR _0928_/C sky130_fd_sc_hd__nand2_2
XFILLER_23_122 VGND VGND VPWR VPWR sky130_fd_sc_hd__decap_3
X_1298_ clkload5/A _1298_/D wire65/X VGND VGND VPWR VPWR _1298_/Q sky130_fd_sc_hd__dfrtp_2
XFILLER_23_155 VGND VGND VPWR VPWR sky130_fd_sc_hd__decap_3
XFILLER_23_199 VGND VGND VPWR VPWR sky130_fd_sc_hd__decap_3
XFILLER_11_44 VGND VGND VPWR VPWR sky130_fd_sc_hd__fill_2
XFILLER_11_55 VGND VGND VPWR VPWR sky130_fd_sc_hd__fill_1
XFILLER_11_66 VGND VGND VPWR VPWR sky130_fd_sc_hd__decap_3
XFILLER_46_203 VGND VGND VPWR VPWR sky130_fd_sc_hd__decap_3
XFILLER_46_236 VGND VGND VPWR VPWR sky130_fd_sc_hd__decap_3
XFILLER_14_100 VGND VGND VPWR VPWR sky130_fd_sc_hd__fill_2
XFILLER_36_41 VGND VGND VPWR VPWR sky130_fd_sc_hd__decap_3
XFILLER_36_74 VGND VGND VPWR VPWR sky130_fd_sc_hd__decap_3
XFILLER_36_85 VGND VGND VPWR VPWR sky130_fd_sc_hd__decap_3
Xinput16 b_in[7] VGND VGND VPWR VPWR _1297_/D sky130_fd_sc_hd__clkdlybuf4s25_1
XFILLER_35_6 VGND VGND VPWR VPWR sky130_fd_sc_hd__decap_3
X_1221_ _1221_/A _1221_/B VGND VGND VPWR VPWR _1221_/Y sky130_fd_sc_hd__nor2_4
XFILLER_37_225 VGND VGND VPWR VPWR sky130_fd_sc_hd__decap_3
X_1083_ _1083_/A _1083_/B _1083_/C _1083_/D VGND VGND VPWR VPWR _1085_/A sky130_fd_sc_hd__and4_4
X_1152_ _1303_/Q _1271_/Q VGND VGND VPWR VPWR _1250_/B sky130_fd_sc_hd__and2_2
XFILLER_20_103 VGND VGND VPWR VPWR sky130_fd_sc_hd__fill_2
XFILLER_20_158 VGND VGND VPWR VPWR sky130_fd_sc_hd__decap_3
XFILLER_20_169 VGND VGND VPWR VPWR sky130_fd_sc_hd__fill_1
X_0936_ _0942_/B _1007_/A _1010_/A VGND VGND VPWR VPWR _0947_/B sky130_fd_sc_hd__nand3_4
X_0867_ _0778_/A _0922_/B _0783_/Y _0784_/Y VGND VGND VPWR VPWR _0867_/X sky130_fd_sc_hd__o211a_2
X_0798_ _0796_/X _0797_/Y _0801_/A _0801_/B VGND VGND VPWR VPWR _0799_/B sky130_fd_sc_hd__o211a_2
XPHY_EDGE_ROW_21_Left_70 VGND VGND VPWR VPWR sky130_fd_sc_hd__decap_3
XFILLER_28_203 VGND VGND VPWR VPWR sky130_fd_sc_hd__decap_3
XFILLER_36_280 VGND VGND VPWR VPWR sky130_fd_sc_hd__decap_3
XFILLER_43_228 VGND VGND VPWR VPWR sky130_fd_sc_hd__decap_3
XTAP_TAPCELL_ROW_38_297 VGND VPWR sky130_fd_sc_hd__tapvpwrvgnd_1
XFILLER_11_169 VGND VGND VPWR VPWR sky130_fd_sc_hd__decap_3
XFILLER_0_3 VGND VGND VPWR VPWR sky130_fd_sc_hd__decap_3
XFILLER_34_206 VGND VGND VPWR VPWR sky130_fd_sc_hd__fill_1
XFILLER_42_250 VGND VGND VPWR VPWR sky130_fd_sc_hd__fill_2
XFILLER_42_283 VGND VGND VPWR VPWR sky130_fd_sc_hd__decap_3
X_0721_ _0712_/B _0716_/Y _0704_/X _0705_/X VGND VGND VPWR VPWR _0721_/Y sky130_fd_sc_hd__o211ai_2
X_0652_ _0652_/A _0652_/B VGND VGND VPWR VPWR _0652_/Y sky130_fd_sc_hd__nand2_2
XTAP_TAPCELL_ROW_12_164 VGND VPWR sky130_fd_sc_hd__tapvpwrvgnd_1
XFILLER_8_78 VGND VGND VPWR VPWR sky130_fd_sc_hd__decap_3
XFILLER_6_162 VGND VGND VPWR VPWR sky130_fd_sc_hd__decap_3
X_1204_ _1260_/Q _1278_/Q VGND VGND VPWR VPWR _1205_/B sky130_fd_sc_hd__nor2_2
XFILLER_25_239 VGND VGND VPWR VPWR sky130_fd_sc_hd__fill_2
XFILLER_40_209 VGND VGND VPWR VPWR sky130_fd_sc_hd__fill_1
X_1135_ _1120_/X _1103_/C _1119_/C _1119_/D VGND VGND VPWR VPWR _1137_/A sky130_fd_sc_hd__o211ai_2
X_1066_ _0993_/B _0993_/A _0993_/C _1047_/B _1047_/A VGND VGND VPWR VPWR _1066_/X
+ sky130_fd_sc_hd__a32o_2
XTAP_TAPCELL_ROW_35_278 VGND VPWR sky130_fd_sc_hd__tapvpwrvgnd_1
X_0919_ _0922_/A _0922_/B _0918_/Y VGND VGND VPWR VPWR _0919_/Y sky130_fd_sc_hd__o21ai_4
XFILLER_16_217 VGND VGND VPWR VPWR sky130_fd_sc_hd__decap_3
XFILLER_17_43 VGND VGND VPWR VPWR sky130_fd_sc_hd__decap_3
XTAP_TAPCELL_ROW_3_121 VGND VPWR sky130_fd_sc_hd__tapvpwrvgnd_1
XFILLER_17_98 VGND VGND VPWR VPWR sky130_fd_sc_hd__decap_3
XFILLER_24_250 VGND VGND VPWR VPWR sky130_fd_sc_hd__fill_2
XFILLER_24_272 VGND VGND VPWR VPWR sky130_fd_sc_hd__decap_3
XTAP_TAPCELL_ROW_26_234 VGND VPWR sky130_fd_sc_hd__tapvpwrvgnd_1
XFILLER_3_110 VGND VGND VPWR VPWR sky130_fd_sc_hd__fill_2
XFILLER_3_154 VGND VGND VPWR VPWR sky130_fd_sc_hd__fill_1
XFILLER_3_176 VGND VGND VPWR VPWR sky130_fd_sc_hd__fill_2
XFILLER_22_209 VGND VGND VPWR VPWR sky130_fd_sc_hd__decap_3
XFILLER_30_242 VGND VGND VPWR VPWR sky130_fd_sc_hd__decap_3
XFILLER_30_253 VGND VGND VPWR VPWR sky130_fd_sc_hd__fill_2
X_0704_ _0704_/A _1044_/A VGND VGND VPWR VPWR _0704_/X sky130_fd_sc_hd__and2_2
X_0635_ _1140_/A _0704_/A _0642_/B VGND VGND VPWR VPWR _1266_/D sky130_fd_sc_hd__and3_2
XTAP_TAPCELL_ROW_0_102 VGND VPWR sky130_fd_sc_hd__tapvpwrvgnd_1
XFILLER_21_264 VGND VGND VPWR VPWR sky130_fd_sc_hd__decap_3
X_1118_ _1120_/B _1119_/C _1119_/D _1119_/A VGND VGND VPWR VPWR _1123_/B sky130_fd_sc_hd__a22o_2
X_1049_ _1049_/A _1049_/B _1065_/A _1049_/D VGND VGND VPWR VPWR _1064_/B sky130_fd_sc_hd__nand4_2
XFILLER_21_275 VGND VGND VPWR VPWR sky130_fd_sc_hd__decap_3
XFILLER_0_102 VGND VGND VPWR VPWR sky130_fd_sc_hd__fill_1
XFILLER_0_113 VGND VGND VPWR VPWR sky130_fd_sc_hd__fill_2
XFILLER_0_135 VGND VGND VPWR VPWR sky130_fd_sc_hd__decap_3
XFILLER_28_97 VGND VGND VPWR VPWR sky130_fd_sc_hd__decap_3
XFILLER_12_242 VGND VGND VPWR VPWR sky130_fd_sc_hd__fill_1
XFILLER_44_85 VGND VGND VPWR VPWR sky130_fd_sc_hd__decap_3
XFILLER_8_235 VGND VGND VPWR VPWR sky130_fd_sc_hd__decap_3
XFILLER_5_79 VGND VGND VPWR VPWR sky130_fd_sc_hd__decap_3
XFILLER_5_57 VGND VGND VPWR VPWR sky130_fd_sc_hd__decap_3
XFILLER_39_139 VGND VGND VPWR VPWR sky130_fd_sc_hd__fill_1
XFILLER_47_172 VGND VGND VPWR VPWR sky130_fd_sc_hd__decap_3
XTAP_TAPCELL_ROW_20_207 VGND VPWR sky130_fd_sc_hd__tapvpwrvgnd_1
XFILLER_38_150 VGND VGND VPWR VPWR sky130_fd_sc_hd__fill_2
XFILLER_45_109 VGND VGND VPWR VPWR sky130_fd_sc_hd__decap_3
XFILLER_14_11 VGND VGND VPWR VPWR sky130_fd_sc_hd__decap_3
XFILLER_14_77 VGND VGND VPWR VPWR sky130_fd_sc_hd__decap_3
XFILLER_14_88 VGND VGND VPWR VPWR sky130_fd_sc_hd__decap_3
XFILLER_30_21 VGND VGND VPWR VPWR sky130_fd_sc_hd__decap_3
XFILLER_30_32 VGND VGND VPWR VPWR sky130_fd_sc_hd__decap_3
XFILLER_5_238 VGND VGND VPWR VPWR sky130_fd_sc_hd__decap_3
XFILLER_29_150 VGND VGND VPWR VPWR sky130_fd_sc_hd__fill_1
XFILLER_4_282 VGND VGND VPWR VPWR sky130_fd_sc_hd__decap_3
XFILLER_35_164 VGND VGND VPWR VPWR sky130_fd_sc_hd__decap_3
XFILLER_35_186 VGND VGND VPWR VPWR sky130_fd_sc_hd__decap_3
XFILLER_25_54 VGND VGND VPWR VPWR sky130_fd_sc_hd__fill_2
XFILLER_26_164 VGND VGND VPWR VPWR sky130_fd_sc_hd__decap_3
XFILLER_26_197 VGND VGND VPWR VPWR sky130_fd_sc_hd__decap_3
Xrebuffer94 _1286_/Q VGND VGND VPWR VPWR _0713_/C sky130_fd_sc_hd__buf_2
Xrebuffer83 _0811_/Y VGND VGND VPWR VPWR _1030_/A2 sky130_fd_sc_hd__buf_2
XFILLER_41_178 VGND VGND VPWR VPWR sky130_fd_sc_hd__decap_3
XFILLER_41_31 VGND VGND VPWR VPWR sky130_fd_sc_hd__decap_3
XFILLER_41_75 VGND VGND VPWR VPWR sky130_fd_sc_hd__decap_3
Xrebuffer162 _1158_/Y VGND VGND VPWR VPWR _1240_/A2 sky130_fd_sc_hd__buf_2
XFILLER_17_131 VGND VGND VPWR VPWR sky130_fd_sc_hd__decap_3
XFILLER_17_153 VGND VGND VPWR VPWR sky130_fd_sc_hd__decap_3
XFILLER_32_112 VGND VGND VPWR VPWR sky130_fd_sc_hd__decap_3
X_0952_ _1058_/B _1058_/A _0871_/X _0875_/X VGND VGND VPWR VPWR _0952_/Y sky130_fd_sc_hd__o2bb2ai_2
X_0883_ _1058_/B _0881_/Y _0882_/Y VGND VGND VPWR VPWR _1273_/D sky130_fd_sc_hd__o21a_2
X_1297_ clkload2/A _1297_/D fanout73/X VGND VGND VPWR VPWR _1297_/Q sky130_fd_sc_hd__dfrtp_2
XFILLER_11_12 VGND VGND VPWR VPWR sky130_fd_sc_hd__decap_3
XFILLER_23_167 VGND VGND VPWR VPWR sky130_fd_sc_hd__fill_1
XFILLER_23_178 VGND VGND VPWR VPWR sky130_fd_sc_hd__decap_3
XFILLER_36_53 VGND VGND VPWR VPWR sky130_fd_sc_hd__decap_3
XFILLER_46_215 VGND VGND VPWR VPWR sky130_fd_sc_hd__decap_3
XFILLER_46_248 VGND VGND VPWR VPWR sky130_fd_sc_hd__decap_3
XFILLER_46_259 VGND VGND VPWR VPWR sky130_fd_sc_hd__decap_3
XFILLER_14_112 VGND VGND VPWR VPWR sky130_fd_sc_hd__decap_3
XFILLER_14_189 VGND VGND VPWR VPWR sky130_fd_sc_hd__decap_3
Xinput17 rst_n VGND VGND VPWR VPWR input17/X sky130_fd_sc_hd__clkdlybuf4s25_1
X_1151_ _1304_/Q _1272_/Q VGND VGND VPWR VPWR _1171_/C sky130_fd_sc_hd__nand2_2
X_1220_ _1218_/X _1255_/A2 _1219_/Y wire55/X _1262_/Q VGND VGND VPWR VPWR _1262_/D
+ sky130_fd_sc_hd__a32o_2
XFILLER_37_259 VGND VGND VPWR VPWR sky130_fd_sc_hd__decap_3
XFILLER_45_270 VGND VGND VPWR VPWR sky130_fd_sc_hd__decap_3
XFILLER_45_281 VGND VGND VPWR VPWR sky130_fd_sc_hd__decap_3
X_1082_ wire52/X _1082_/B _1082_/C VGND VGND VPWR VPWR _1083_/D sky130_fd_sc_hd__nand3_2
XFILLER_20_126 VGND VGND VPWR VPWR sky130_fd_sc_hd__decap_3
X_0935_ _1007_/A _1010_/A _0942_/B VGND VGND VPWR VPWR _0947_/A sky130_fd_sc_hd__a21o_4
X_0866_ _0866_/A _0866_/B _0866_/C VGND VGND VPWR VPWR _0866_/Y sky130_fd_sc_hd__nand3_4
X_0797_ _0870_/A _0930_/B _0788_/Y _0793_/X VGND VGND VPWR VPWR _0797_/Y sky130_fd_sc_hd__a211oi_2
XFILLER_28_215 VGND VGND VPWR VPWR sky130_fd_sc_hd__decap_3
XFILLER_28_226 VGND VGND VPWR VPWR sky130_fd_sc_hd__fill_1
XFILLER_11_137 VGND VGND VPWR VPWR sky130_fd_sc_hd__decap_3
XFILLER_43_218 VGND VGND VPWR VPWR sky130_fd_sc_hd__decap_3
Xwire52 wire52/A VGND VGND VPWR VPWR wire52/X sky130_fd_sc_hd__buf_1
XFILLER_22_88 VGND VGND VPWR VPWR sky130_fd_sc_hd__decap_3
XFILLER_19_259 VGND VGND VPWR VPWR sky130_fd_sc_hd__decap_3
XFILLER_27_281 VGND VGND VPWR VPWR sky130_fd_sc_hd__decap_3
XFILLER_47_63 VGND VGND VPWR VPWR sky130_fd_sc_hd__decap_3
XFILLER_42_262 VGND VGND VPWR VPWR sky130_fd_sc_hd__decap_3
X_0720_ _0680_/A _0680_/B _0712_/B _0711_/Y VGND VGND VPWR VPWR _0720_/X sky130_fd_sc_hd__a2bb2o_4
XTAP_TAPCELL_ROW_12_165 VGND VPWR sky130_fd_sc_hd__tapvpwrvgnd_1
XFILLER_8_57 VGND VGND VPWR VPWR sky130_fd_sc_hd__decap_3
XFILLER_8_35 VGND VGND VPWR VPWR sky130_fd_sc_hd__decap_3
XFILLER_8_24 VGND VGND VPWR VPWR sky130_fd_sc_hd__decap_3
X_0651_ _0663_/B _0650_/B _1282_/Q _1098_/A VGND VGND VPWR VPWR _0652_/B sky130_fd_sc_hd__a2bb2o_2
XFILLER_6_141 VGND VGND VPWR VPWR sky130_fd_sc_hd__decap_3
XFILLER_6_130 VGND VGND VPWR VPWR sky130_fd_sc_hd__decap_3
XFILLER_26_3 VGND VGND VPWR VPWR sky130_fd_sc_hd__decap_3
X_1134_ _1111_/B _1125_/Y _1111_/A _1129_/A VGND VGND VPWR VPWR _1142_/A sky130_fd_sc_hd__o31a_2
X_1203_ _1260_/Q _1278_/Q VGND VGND VPWR VPWR _1210_/A sky130_fd_sc_hd__and2_2
XFILLER_18_270 VGND VGND VPWR VPWR sky130_fd_sc_hd__decap_3
XFILLER_33_273 VGND VGND VPWR VPWR sky130_fd_sc_hd__decap_3
XFILLER_33_284 VGND VGND VPWR VPWR sky130_fd_sc_hd__fill_2
X_1065_ _1065_/A VGND VGND VPWR VPWR _1065_/Y sky130_fd_sc_hd__inv_2
XTAP_TAPCELL_ROW_35_279 VGND VPWR sky130_fd_sc_hd__tapvpwrvgnd_1
X_0918_ _0916_/Y _0917_/Y _0921_/B _0990_/B VGND VGND VPWR VPWR _0918_/Y sky130_fd_sc_hd__o211ai_2
X_0849_ _0849_/A _0849_/B VGND VGND VPWR VPWR _0849_/Y sky130_fd_sc_hd__nand2_2
XFILLER_16_229 VGND VGND VPWR VPWR sky130_fd_sc_hd__fill_2
XFILLER_17_55 VGND VGND VPWR VPWR sky130_fd_sc_hd__fill_1
XFILLER_17_66 VGND VGND VPWR VPWR sky130_fd_sc_hd__decap_3
XTAP_TAPCELL_ROW_3_122 VGND VPWR sky130_fd_sc_hd__tapvpwrvgnd_1
XTAP_TAPCELL_ROW_26_235 VGND VPWR sky130_fd_sc_hd__tapvpwrvgnd_1
XFILLER_24_262 VGND VGND VPWR VPWR sky130_fd_sc_hd__fill_1
XFILLER_24_284 VGND VGND VPWR VPWR sky130_fd_sc_hd__fill_2
XFILLER_33_98 VGND VGND VPWR VPWR sky130_fd_sc_hd__decap_3
XFILLER_3_122 VGND VGND VPWR VPWR sky130_fd_sc_hd__fill_2
XFILLER_12_9 VGND VGND VPWR VPWR sky130_fd_sc_hd__decap_3
XFILLER_15_262 VGND VGND VPWR VPWR sky130_fd_sc_hd__decap_3
XFILLER_15_284 VGND VGND VPWR VPWR sky130_fd_sc_hd__fill_2
XFILLER_30_210 VGND VGND VPWR VPWR sky130_fd_sc_hd__decap_3
X_0703_ _0702_/X _0697_/A _0697_/B _0672_/X VGND VGND VPWR VPWR _0703_/X sky130_fd_sc_hd__o31a_2
X_0634_ _1282_/Q VGND VGND VPWR VPWR _0642_/B sky130_fd_sc_hd__clkbuf_1
X_1117_ _1117_/A _1117_/B _1131_/A VGND VGND VPWR VPWR _1278_/D sky130_fd_sc_hd__nor3b_2
XTAP_TAPCELL_ROW_0_103 VGND VPWR sky130_fd_sc_hd__tapvpwrvgnd_1
XFILLER_21_243 VGND VGND VPWR VPWR sky130_fd_sc_hd__fill_1
X_1048_ _1049_/B _1065_/A _1049_/D _1049_/A VGND VGND VPWR VPWR _1064_/A sky130_fd_sc_hd__a22o_2
XTAP_TAPCELL_ROW_31_260 VGND VPWR sky130_fd_sc_hd__tapvpwrvgnd_1
XPHY_EDGE_ROW_3_Right_3 VGND VGND VPWR VPWR sky130_fd_sc_hd__decap_3
XFILLER_0_169 VGND VGND VPWR VPWR sky130_fd_sc_hd__decap_3
XFILLER_28_32 VGND VGND VPWR VPWR sky130_fd_sc_hd__fill_2
XFILLER_12_221 VGND VGND VPWR VPWR sky130_fd_sc_hd__decap_3
XFILLER_44_42 VGND VGND VPWR VPWR sky130_fd_sc_hd__decap_3
XFILLER_44_75 VGND VGND VPWR VPWR sky130_fd_sc_hd__decap_3
XFILLER_8_203 VGND VGND VPWR VPWR sky130_fd_sc_hd__decap_3
XFILLER_5_47 VGND VGND VPWR VPWR sky130_fd_sc_hd__decap_3
XFILLER_10_6 VGND VGND VPWR VPWR sky130_fd_sc_hd__decap_3
XFILLER_47_184 VGND VGND VPWR VPWR sky130_fd_sc_hd__decap_3
XTAP_TAPCELL_ROW_45_330 VGND VPWR sky130_fd_sc_hd__tapvpwrvgnd_1
XFILLER_14_45 VGND VGND VPWR VPWR sky130_fd_sc_hd__fill_2
XFILLER_14_56 VGND VGND VPWR VPWR sky130_fd_sc_hd__decap_3
XFILLER_30_88 VGND VGND VPWR VPWR sky130_fd_sc_hd__decap_3
XFILLER_29_162 VGND VGND VPWR VPWR sky130_fd_sc_hd__decap_3
XFILLER_29_195 VGND VGND VPWR VPWR sky130_fd_sc_hd__decap_3
XFILLER_44_154 VGND VGND VPWR VPWR sky130_fd_sc_hd__fill_2
XFILLER_26_110 VGND VGND VPWR VPWR sky130_fd_sc_hd__fill_2
XFILLER_41_113 VGND VGND VPWR VPWR sky130_fd_sc_hd__decap_3
Xrebuffer95 _0832_/Y VGND VGND VPWR VPWR _0838_/A1 sky130_fd_sc_hd__buf_4
Xrebuffer84 _0990_/B VGND VGND VPWR VPWR _0987_/A sky130_fd_sc_hd__buf_4
XFILLER_41_43 VGND VGND VPWR VPWR sky130_fd_sc_hd__decap_3
XFILLER_41_54 VGND VGND VPWR VPWR sky130_fd_sc_hd__fill_2
XFILLER_41_87 VGND VGND VPWR VPWR sky130_fd_sc_hd__decap_3
Xrebuffer163 _1199_/B VGND VGND VPWR VPWR _1193_/A1 sky130_fd_sc_hd__buf_2
XFILLER_1_231 VGND VGND VPWR VPWR sky130_fd_sc_hd__decap_3
XFILLER_1_253 VGND VGND VPWR VPWR sky130_fd_sc_hd__decap_3
XFILLER_17_187 VGND VGND VPWR VPWR sky130_fd_sc_hd__decap_3
X_0951_ _0938_/X _0946_/Y _0950_/Y VGND VGND VPWR VPWR _0951_/Y sky130_fd_sc_hd__o21ai_2
X_0882_ _0881_/Y _1058_/B _1117_/A VGND VGND VPWR VPWR _0882_/Y sky130_fd_sc_hd__a21oi_2
X_1296_ clkload0/A _1296_/D fanout73/X VGND VGND VPWR VPWR _1296_/Q sky130_fd_sc_hd__dfrtp_2
XFILLER_23_113 VGND VGND VPWR VPWR sky130_fd_sc_hd__decap_3
XTAP_TAPCELL_ROW_18_193 VGND VPWR sky130_fd_sc_hd__tapvpwrvgnd_1
XFILLER_11_57 VGND VGND VPWR VPWR sky130_fd_sc_hd__decap_3
XFILLER_36_32 VGND VGND VPWR VPWR sky130_fd_sc_hd__decap_3
XFILLER_36_65 VGND VGND VPWR VPWR sky130_fd_sc_hd__decap_3
XFILLER_46_227 VGND VGND VPWR VPWR sky130_fd_sc_hd__decap_3
XFILLER_14_157 VGND VGND VPWR VPWR sky130_fd_sc_hd__decap_3
XFILLER_42_9 VGND VGND VPWR VPWR sky130_fd_sc_hd__decap_3
XTAP_TAPCELL_ROW_9_150 VGND VPWR sky130_fd_sc_hd__tapvpwrvgnd_1
X_1150_ _1305_/Q _1273_/Q VGND VGND VPWR VPWR _1150_/X sky130_fd_sc_hd__and2_2
X_1081_ _1081_/A _1297_/Q _1081_/C _1081_/D VGND VGND VPWR VPWR _1083_/C sky130_fd_sc_hd__nand4_2
X_0934_ _0855_/Y _0934_/A2_N _0847_/Y _0934_/B2 VGND VGND VPWR VPWR _0942_/B sky130_fd_sc_hd__a2bb2oi_4
X_0865_ _0856_/Y _0855_/Y _0857_/X _0847_/Y VGND VGND VPWR VPWR _0866_/A sky130_fd_sc_hd__o211ai_4
XFILLER_9_172 VGND VGND VPWR VPWR sky130_fd_sc_hd__decap_3
XFILLER_9_161 VGND VGND VPWR VPWR sky130_fd_sc_hd__decap_3
X_0796_ _0788_/Y _0793_/X _0870_/A _0930_/B VGND VGND VPWR VPWR _0796_/X sky130_fd_sc_hd__o211a_4
XFILLER_28_249 VGND VGND VPWR VPWR sky130_fd_sc_hd__decap_3
XFILLER_36_271 VGND VGND VPWR VPWR sky130_fd_sc_hd__decap_3
X_1279_ clkload5/A _1279_/D wire68/X VGND VGND VPWR VPWR _1279_/Q sky130_fd_sc_hd__dfrtp_2
XFILLER_11_116 VGND VGND VPWR VPWR sky130_fd_sc_hd__decap_3
XFILLER_11_127 VGND VGND VPWR VPWR sky130_fd_sc_hd__fill_1
XFILLER_22_45 VGND VGND VPWR VPWR sky130_fd_sc_hd__decap_3
XFILLER_22_56 VGND VGND VPWR VPWR sky130_fd_sc_hd__decap_3
XFILLER_47_53 VGND VGND VPWR VPWR sky130_fd_sc_hd__decap_3
XFILLER_42_241 VGND VGND VPWR VPWR sky130_fd_sc_hd__decap_3
XFILLER_47_75 VGND VGND VPWR VPWR sky130_fd_sc_hd__decap_3
XFILLER_10_160 VGND VGND VPWR VPWR sky130_fd_sc_hd__decap_3
XFILLER_42_274 VGND VGND VPWR VPWR sky130_fd_sc_hd__decap_3
XTAP_TAPCELL_ROW_12_166 VGND VPWR sky130_fd_sc_hd__tapvpwrvgnd_1
XFILLER_8_69 VGND VGND VPWR VPWR sky130_fd_sc_hd__decap_3
XFILLER_8_47 VGND VGND VPWR VPWR sky130_fd_sc_hd__decap_3
XFILLER_8_14 VGND VGND VPWR VPWR sky130_fd_sc_hd__decap_3
XFILLER_6_153 VGND VGND VPWR VPWR sky130_fd_sc_hd__decap_3
XFILLER_6_120 VGND VGND VPWR VPWR sky130_fd_sc_hd__fill_2
X_0650_ _0663_/B _0650_/B _1282_/Q _1098_/A VGND VGND VPWR VPWR _0652_/A sky130_fd_sc_hd__or4bb_4
XFILLER_6_197 VGND VGND VPWR VPWR sky130_fd_sc_hd__decap_3
XFILLER_19_3 VGND VGND VPWR VPWR sky130_fd_sc_hd__decap_3
X_1133_ _1139_/A _1133_/B _1133_/C VGND VGND VPWR VPWR _1279_/D sky130_fd_sc_hd__and3_4
X_1202_ _1259_/Q _1277_/Q _1197_/X VGND VGND VPWR VPWR _1202_/Y sky130_fd_sc_hd__a21oi_2
X_1064_ _1064_/A _1064_/B VGND VGND VPWR VPWR _1064_/Y sky130_fd_sc_hd__nand2_4
XFILLER_18_282 VGND VGND VPWR VPWR sky130_fd_sc_hd__decap_3
X_0917_ _0917_/A1 _0917_/A2 _0829_/Y VGND VGND VPWR VPWR _0917_/Y sky130_fd_sc_hd__a21oi_4
X_0848_ _0828_/Y _0835_/Y _0844_/A _0839_/Y VGND VGND VPWR VPWR _0848_/Y sky130_fd_sc_hd__o211ai_4
X_0779_ _0783_/A _0783_/B VGND VGND VPWR VPWR _0781_/A sky130_fd_sc_hd__nand2_2
XFILLER_16_208 VGND VGND VPWR VPWR sky130_fd_sc_hd__decap_3
XFILLER_17_12 VGND VGND VPWR VPWR sky130_fd_sc_hd__fill_2
XFILLER_17_34 VGND VGND VPWR VPWR sky130_fd_sc_hd__decap_3
XFILLER_17_89 VGND VGND VPWR VPWR sky130_fd_sc_hd__decap_3
XTAP_TAPCELL_ROW_26_236 VGND VPWR sky130_fd_sc_hd__tapvpwrvgnd_1
XPHY_EDGE_ROW_9_Left_58 VGND VGND VPWR VPWR sky130_fd_sc_hd__decap_3
XFILLER_33_11 VGND VGND VPWR VPWR sky130_fd_sc_hd__decap_3
XFILLER_33_55 VGND VGND VPWR VPWR sky130_fd_sc_hd__fill_1
XFILLER_15_241 VGND VGND VPWR VPWR sky130_fd_sc_hd__decap_3
XFILLER_15_274 VGND VGND VPWR VPWR sky130_fd_sc_hd__decap_3
XFILLER_30_200 VGND VGND VPWR VPWR sky130_fd_sc_hd__fill_2
XFILLER_30_233 VGND VGND VPWR VPWR sky130_fd_sc_hd__decap_3
XFILLER_30_277 VGND VGND VPWR VPWR sky130_fd_sc_hd__decap_3
X_0702_ _0870_/A _1067_/A VGND VGND VPWR VPWR _0702_/X sky130_fd_sc_hd__and2_2
X_0633_ _1024_/A VGND VGND VPWR VPWR _0704_/A sky130_fd_sc_hd__buf_6
X_1116_ _1115_/A _1115_/C _1115_/B VGND VGND VPWR VPWR _1131_/A sky130_fd_sc_hd__o21ai_2
X_1047_ _1047_/A _1047_/B VGND VGND VPWR VPWR _1049_/D sky130_fd_sc_hd__nand2_2
XTAP_TAPCELL_ROW_48_350 VGND VPWR sky130_fd_sc_hd__tapvpwrvgnd_1
XTAP_TAPCELL_ROW_0_104 VGND VPWR sky130_fd_sc_hd__tapvpwrvgnd_1
XTAP_TAPCELL_ROW_31_261 VGND VPWR sky130_fd_sc_hd__tapvpwrvgnd_1
XFILLER_0_126 VGND VGND VPWR VPWR sky130_fd_sc_hd__fill_1
XFILLER_0_159 VGND VGND VPWR VPWR sky130_fd_sc_hd__fill_1
XFILLER_28_11 VGND VGND VPWR VPWR sky130_fd_sc_hd__decap_3
XFILLER_48_119 VGND VGND VPWR VPWR sky130_fd_sc_hd__fill_1
XFILLER_12_233 VGND VGND VPWR VPWR sky130_fd_sc_hd__decap_3
XFILLER_44_21 VGND VGND VPWR VPWR sky130_fd_sc_hd__decap_3
XFILLER_44_54 VGND VGND VPWR VPWR sky130_fd_sc_hd__decap_3
XFILLER_8_259 VGND VGND VPWR VPWR sky130_fd_sc_hd__decap_3
Xsplit124 _0899_/B VGND VGND VPWR VPWR _0967_/C sky130_fd_sc_hd__clkbuf_2
XFILLER_47_152 VGND VGND VPWR VPWR sky130_fd_sc_hd__decap_3
XFILLER_47_196 VGND VGND VPWR VPWR sky130_fd_sc_hd__fill_2
XTAP_TAPCELL_ROW_45_331 VGND VPWR sky130_fd_sc_hd__tapvpwrvgnd_1
XPHY_EDGE_ROW_13_Right_13 VGND VGND VPWR VPWR sky130_fd_sc_hd__decap_3
XPHY_EDGE_ROW_22_Right_22 VGND VGND VPWR VPWR sky130_fd_sc_hd__decap_3
XFILLER_7_281 VGND VGND VPWR VPWR sky130_fd_sc_hd__decap_3
XFILLER_38_130 VGND VGND VPWR VPWR sky130_fd_sc_hd__decap_3
XFILLER_38_141 VGND VGND VPWR VPWR sky130_fd_sc_hd__decap_3
XPHY_EDGE_ROW_31_Right_31 VGND VGND VPWR VPWR sky130_fd_sc_hd__decap_3
XFILLER_14_35 VGND VGND VPWR VPWR sky130_fd_sc_hd__fill_1
XFILLER_30_12 VGND VGND VPWR VPWR sky130_fd_sc_hd__decap_3
XFILLER_30_45 VGND VGND VPWR VPWR sky130_fd_sc_hd__decap_3
XPHY_EDGE_ROW_40_Right_40 VGND VGND VPWR VPWR sky130_fd_sc_hd__decap_3
XFILLER_30_78 VGND VGND VPWR VPWR sky130_fd_sc_hd__decap_3
XFILLER_35_111 VGND VGND VPWR VPWR sky130_fd_sc_hd__fill_1
XFILLER_35_177 VGND VGND VPWR VPWR sky130_fd_sc_hd__decap_3
XFILLER_25_12 VGND VGND VPWR VPWR sky130_fd_sc_hd__decap_3
XFILLER_25_78 VGND VGND VPWR VPWR sky130_fd_sc_hd__decap_3
XFILLER_41_11 VGND VGND VPWR VPWR sky130_fd_sc_hd__fill_2
XFILLER_41_169 VGND VGND VPWR VPWR sky130_fd_sc_hd__decap_3
Xrebuffer96 _1085_/B VGND VGND VPWR VPWR _1088_/A1 sky130_fd_sc_hd__buf_2
Xrebuffer85 _0659_/Y VGND VGND VPWR VPWR _0723_/B1 sky130_fd_sc_hd__buf_2
Xrebuffer74 _0949_/Y VGND VGND VPWR VPWR _0950_/B sky130_fd_sc_hd__buf_2
Xrebuffer164 _1267_/Q VGND VGND VPWR VPWR _1156_/B sky130_fd_sc_hd__buf_2
Xrebuffer120 _0683_/B VGND VGND VPWR VPWR _0684_/A2 sky130_fd_sc_hd__buf_6
XPHY_EDGE_ROW_38_Left_87 VGND VGND VPWR VPWR sky130_fd_sc_hd__decap_3
XFILLER_2_27 VGND VGND VPWR VPWR sky130_fd_sc_hd__fill_1
XFILLER_17_122 VGND VGND VPWR VPWR sky130_fd_sc_hd__decap_3
XFILLER_32_103 VGND VGND VPWR VPWR sky130_fd_sc_hd__decap_3
X_0950_ _0950_/A _0950_/B VGND VGND VPWR VPWR _0950_/Y sky130_fd_sc_hd__nand2_2
X_0881_ _0875_/X _0871_/X _1058_/A VGND VGND VPWR VPWR _0881_/Y sky130_fd_sc_hd__o21ai_2
X_1295_ clkload3/A _1295_/D wire72/A VGND VGND VPWR VPWR _1295_/Q sky130_fd_sc_hd__dfrtp_2
XFILLER_23_125 VGND VGND VPWR VPWR sky130_fd_sc_hd__decap_3
XFILLER_23_158 VGND VGND VPWR VPWR sky130_fd_sc_hd__decap_3
XFILLER_23_169 VGND VGND VPWR VPWR sky130_fd_sc_hd__decap_3
XTAP_TAPCELL_ROW_18_194 VGND VPWR sky130_fd_sc_hd__tapvpwrvgnd_1
XFILLER_11_69 VGND VGND VPWR VPWR sky130_fd_sc_hd__fill_2
XFILLER_46_206 VGND VGND VPWR VPWR sky130_fd_sc_hd__decap_3
XFILLER_36_44 VGND VGND VPWR VPWR sky130_fd_sc_hd__decap_3
XFILLER_36_77 VGND VGND VPWR VPWR sky130_fd_sc_hd__decap_3
XFILLER_36_88 VGND VGND VPWR VPWR sky130_fd_sc_hd__fill_1
XFILLER_46_239 VGND VGND VPWR VPWR sky130_fd_sc_hd__decap_3
XFILLER_22_191 VGND VGND VPWR VPWR sky130_fd_sc_hd__fill_2
XFILLER_35_9 VGND VGND VPWR VPWR sky130_fd_sc_hd__fill_2
XTAP_TAPCELL_ROW_9_151 VGND VPWR sky130_fd_sc_hd__tapvpwrvgnd_1
XFILLER_37_228 VGND VGND VPWR VPWR sky130_fd_sc_hd__decap_3
X_1080_ _1081_/C _1297_/Q _1081_/D _1081_/A VGND VGND VPWR VPWR _1083_/B sky130_fd_sc_hd__a22o_4
XFILLER_45_261 VGND VGND VPWR VPWR sky130_fd_sc_hd__decap_3
XFILLER_13_180 VGND VGND VPWR VPWR sky130_fd_sc_hd__decap_3
X_0933_ _0933_/A _0933_/B _0933_/C VGND VGND VPWR VPWR _1007_/A sky130_fd_sc_hd__nand3_4
X_0864_ _0864_/A _0864_/B VGND VGND VPWR VPWR _0866_/B sky130_fd_sc_hd__nand2_4
X_0795_ _1101_/A VGND VGND VPWR VPWR _1119_/A sky130_fd_sc_hd__clkbuf_1
XFILLER_28_206 VGND VGND VPWR VPWR sky130_fd_sc_hd__decap_3
XFILLER_36_283 VGND VGND VPWR VPWR sky130_fd_sc_hd__decap_3
XFILLER_43_209 VGND VGND VPWR VPWR sky130_fd_sc_hd__fill_2
X_1278_ clkload0/A _1278_/D wire68/X VGND VGND VPWR VPWR _1278_/Q sky130_fd_sc_hd__dfrtp_2
Xwire65 wire65/A VGND VGND VPWR VPWR wire65/X sky130_fd_sc_hd__clkbuf_4
XFILLER_0_6 VGND VGND VPWR VPWR sky130_fd_sc_hd__fill_1
XFILLER_22_68 VGND VGND VPWR VPWR sky130_fd_sc_hd__decap_3
XFILLER_42_220 VGND VGND VPWR VPWR sky130_fd_sc_hd__decap_3
XFILLER_42_253 VGND VGND VPWR VPWR sky130_fd_sc_hd__decap_3
XTAP_TAPCELL_ROW_12_167 VGND VPWR sky130_fd_sc_hd__tapvpwrvgnd_1
XFILLER_6_165 VGND VGND VPWR VPWR sky130_fd_sc_hd__decap_3
X_1201_ _1255_/A2 _1198_/Y _1207_/A1 _1259_/Q wire55/X VGND VGND VPWR VPWR _1259_/D
+ sky130_fd_sc_hd__a32o_2
X_1132_ _1111_/B _1129_/Y _1125_/Y _1111_/A _0630_/A VGND VGND VPWR VPWR _1133_/C
+ sky130_fd_sc_hd__o41a_2
X_1063_ _1063_/A _1063_/B VGND VGND VPWR VPWR _1063_/Y sky130_fd_sc_hd__nand2_2
XPHY_EDGE_ROW_25_Left_74 VGND VGND VPWR VPWR sky130_fd_sc_hd__decap_3
X_0916_ _0814_/A _1081_/C _0819_/B _0915_/X VGND VGND VPWR VPWR _0916_/Y sky130_fd_sc_hd__a22oi_2
X_0847_ _0847_/A _0847_/B _0847_/C VGND VGND VPWR VPWR _0847_/Y sky130_fd_sc_hd__nand3_4
X_0778_ _0778_/A _0922_/B VGND VGND VPWR VPWR _0792_/B sky130_fd_sc_hd__nor2_2
XFILLER_17_46 VGND VGND VPWR VPWR sky130_fd_sc_hd__decap_3
XFILLER_17_57 VGND VGND VPWR VPWR sky130_fd_sc_hd__decap_3
XFILLER_24_253 VGND VGND VPWR VPWR sky130_fd_sc_hd__decap_3
XFILLER_24_275 VGND VGND VPWR VPWR sky130_fd_sc_hd__decap_3
XTAP_TAPCELL_ROW_26_237 VGND VPWR sky130_fd_sc_hd__tapvpwrvgnd_1
XFILLER_15_231 VGND VGND VPWR VPWR sky130_fd_sc_hd__fill_2
XFILLER_15_253 VGND VGND VPWR VPWR sky130_fd_sc_hd__decap_3
XFILLER_30_245 VGND VGND VPWR VPWR sky130_fd_sc_hd__decap_3
X_0701_ _0672_/X _0699_/Y _0700_/Y VGND VGND VPWR VPWR _1270_/D sky130_fd_sc_hd__o21a_2
X_0632_ _0811_/B VGND VGND VPWR VPWR _1024_/A sky130_fd_sc_hd__buf_8
XFILLER_31_3 VGND VGND VPWR VPWR sky130_fd_sc_hd__decap_3
X_1115_ _1115_/A _1115_/B _1115_/C VGND VGND VPWR VPWR _1117_/B sky130_fd_sc_hd__nor3_2
X_1046_ _1046_/A _1046_/B _1046_/C VGND VGND VPWR VPWR _1065_/A sky130_fd_sc_hd__nand3_2
XTAP_TAPCELL_ROW_48_351 VGND VPWR sky130_fd_sc_hd__tapvpwrvgnd_1
XTAP_TAPCELL_ROW_23_218 VGND VPWR sky130_fd_sc_hd__tapvpwrvgnd_1
XTAP_TAPCELL_ROW_0_105 VGND VPWR sky130_fd_sc_hd__tapvpwrvgnd_1
XFILLER_21_267 VGND VGND VPWR VPWR sky130_fd_sc_hd__fill_1
XFILLER_21_278 VGND VGND VPWR VPWR sky130_fd_sc_hd__fill_2
XTAP_TAPCELL_ROW_31_262 VGND VPWR sky130_fd_sc_hd__tapvpwrvgnd_1
XFILLER_0_138 VGND VGND VPWR VPWR sky130_fd_sc_hd__fill_2
XFILLER_0_149 VGND VGND VPWR VPWR sky130_fd_sc_hd__fill_2
XFILLER_44_88 VGND VGND VPWR VPWR sky130_fd_sc_hd__fill_1
XFILLER_8_238 VGND VGND VPWR VPWR sky130_fd_sc_hd__decap_3
XFILLER_47_175 VGND VGND VPWR VPWR sky130_fd_sc_hd__decap_3
XTAP_TAPCELL_ROW_45_332 VGND VPWR sky130_fd_sc_hd__tapvpwrvgnd_1
XFILLER_38_197 VGND VGND VPWR VPWR sky130_fd_sc_hd__decap_3
XFILLER_14_14 VGND VGND VPWR VPWR sky130_fd_sc_hd__decap_3
XFILLER_14_25 VGND VGND VPWR VPWR sky130_fd_sc_hd__decap_3
X_1029_ _1029_/A _1119_/D _1029_/C VGND VGND VPWR VPWR _1029_/X sky130_fd_sc_hd__and3_2
XFILLER_30_24 VGND VGND VPWR VPWR sky130_fd_sc_hd__decap_3
XFILLER_30_35 VGND VGND VPWR VPWR sky130_fd_sc_hd__decap_3
XPHY_EDGE_ROW_12_Left_61 VGND VGND VPWR VPWR sky130_fd_sc_hd__decap_3
XFILLER_29_131 VGND VGND VPWR VPWR sky130_fd_sc_hd__decap_3
XFILLER_29_186 VGND VGND VPWR VPWR sky130_fd_sc_hd__decap_3
XFILLER_44_145 VGND VGND VPWR VPWR sky130_fd_sc_hd__decap_3
XTAP_TAPCELL_ROW_42_313 VGND VPWR sky130_fd_sc_hd__tapvpwrvgnd_1
XFILLER_4_285 VGND VGND VPWR VPWR sky130_fd_sc_hd__fill_1
XFILLER_35_167 VGND VGND VPWR VPWR sky130_fd_sc_hd__fill_1
XFILLER_35_189 VGND VGND VPWR VPWR sky130_fd_sc_hd__decap_3
XFILLER_6_70 VGND VGND VPWR VPWR sky130_fd_sc_hd__decap_3
XFILLER_6_92 VGND VGND VPWR VPWR sky130_fd_sc_hd__decap_3
XFILLER_26_167 VGND VGND VPWR VPWR sky130_fd_sc_hd__decap_3
Xrebuffer97 _1291_/Q VGND VGND VPWR VPWR output27/A sky130_fd_sc_hd__buf_2
Xrebuffer86 _0660_/D VGND VGND VPWR VPWR _0685_/B1 sky130_fd_sc_hd__buf_2
Xrebuffer75 _0931_/Y VGND VGND VPWR VPWR _0998_/B1 sky130_fd_sc_hd__buf_4
Xrebuffer121 _0683_/B VGND VGND VPWR VPWR _0688_/A3 sky130_fd_sc_hd__buf_6
Xrebuffer110 split/X VGND VGND VPWR VPWR _0681_/A sky130_fd_sc_hd__buf_2
XFILLER_41_78 VGND VGND VPWR VPWR sky130_fd_sc_hd__decap_3
Xrebuffer165 _1299_/Q VGND VGND VPWR VPWR _1238_/B1 sky130_fd_sc_hd__buf_2
XFILLER_9_3 VGND VGND VPWR VPWR sky130_fd_sc_hd__decap_3
XFILLER_17_101 VGND VGND VPWR VPWR sky130_fd_sc_hd__fill_2
XFILLER_17_134 VGND VGND VPWR VPWR sky130_fd_sc_hd__decap_3
XFILLER_17_156 VGND VGND VPWR VPWR sky130_fd_sc_hd__decap_3
XFILLER_32_159 VGND VGND VPWR VPWR sky130_fd_sc_hd__decap_3
X_0880_ _0880_/A _0880_/B _0880_/C VGND VGND VPWR VPWR _1058_/A sky130_fd_sc_hd__nand3_4
X_1294_ clkload3/A _1294_/D wire72/X VGND VGND VPWR VPWR _1294_/Q sky130_fd_sc_hd__dfrtp_2
XFILLER_48_281 VGND VGND VPWR VPWR sky130_fd_sc_hd__decap_3
XTAP_TAPCELL_ROW_18_195 VGND VPWR sky130_fd_sc_hd__tapvpwrvgnd_1
XFILLER_46_218 VGND VGND VPWR VPWR sky130_fd_sc_hd__decap_3
XFILLER_14_115 VGND VGND VPWR VPWR sky130_fd_sc_hd__decap_3
XFILLER_14_148 VGND VGND VPWR VPWR sky130_fd_sc_hd__decap_3
XFILLER_36_56 VGND VGND VPWR VPWR sky130_fd_sc_hd__decap_3
XFILLER_39_281 VGND VGND VPWR VPWR sky130_fd_sc_hd__decap_3
XFILLER_22_170 VGND VGND VPWR VPWR sky130_fd_sc_hd__decap_3
XTAP_TAPCELL_ROW_9_152 VGND VPWR sky130_fd_sc_hd__tapvpwrvgnd_1
XFILLER_45_240 VGND VGND VPWR VPWR sky130_fd_sc_hd__decap_3
XFILLER_13_192 VGND VGND VPWR VPWR sky130_fd_sc_hd__decap_3
XFILLER_20_129 VGND VGND VPWR VPWR sky130_fd_sc_hd__decap_3
XFILLER_45_273 VGND VGND VPWR VPWR sky130_fd_sc_hd__decap_3
XFILLER_45_284 VGND VGND VPWR VPWR sky130_fd_sc_hd__fill_2
X_0932_ _0914_/Y _0919_/Y _1004_/A _0931_/Y VGND VGND VPWR VPWR _0933_/C sky130_fd_sc_hd__o211ai_2
XFILLER_9_152 VGND VGND VPWR VPWR sky130_fd_sc_hd__fill_1
X_0863_ _0766_/B _0766_/C _0766_/A _0789_/X _0783_/B VGND VGND VPWR VPWR _0864_/B
+ sky130_fd_sc_hd__a32o_2
X_0794_ _1296_/Q VGND VGND VPWR VPWR _1101_/A sky130_fd_sc_hd__clkbuf_1
XFILLER_36_262 VGND VGND VPWR VPWR sky130_fd_sc_hd__decap_3
X_1277_ clkload2/A _1277_/D fanout70/X VGND VGND VPWR VPWR _1277_/Q sky130_fd_sc_hd__dfrtp_2
Xwire55 wire55/A VGND VGND VPWR VPWR wire55/X sky130_fd_sc_hd__buf_2
XFILLER_22_36 VGND VGND VPWR VPWR sky130_fd_sc_hd__decap_3
XTAP_TAPCELL_ROW_6_133 VGND VPWR sky130_fd_sc_hd__tapvpwrvgnd_1
XFILLER_27_240 VGND VGND VPWR VPWR sky130_fd_sc_hd__decap_3
XFILLER_47_66 VGND VGND VPWR VPWR sky130_fd_sc_hd__decap_3
XFILLER_27_284 VGND VGND VPWR VPWR sky130_fd_sc_hd__fill_2
XFILLER_42_232 VGND VGND VPWR VPWR sky130_fd_sc_hd__decap_3
XFILLER_42_265 VGND VGND VPWR VPWR sky130_fd_sc_hd__decap_3
XTAP_TAPCELL_ROW_37_290 VGND VPWR sky130_fd_sc_hd__tapvpwrvgnd_1
XFILLER_8_38 VGND VGND VPWR VPWR sky130_fd_sc_hd__decap_3
XFILLER_8_27 VGND VGND VPWR VPWR sky130_fd_sc_hd__fill_1
XFILLER_6_144 VGND VGND VPWR VPWR sky130_fd_sc_hd__decap_3
XFILLER_6_133 VGND VGND VPWR VPWR sky130_fd_sc_hd__decap_3
XFILLER_26_6 VGND VGND VPWR VPWR sky130_fd_sc_hd__fill_1
X_1200_ _1200_/A _1200_/B _1200_/C VGND VGND VPWR VPWR _1200_/Y sky130_fd_sc_hd__nand3_4
XFILLER_18_251 VGND VGND VPWR VPWR sky130_fd_sc_hd__fill_1
XFILLER_18_273 VGND VGND VPWR VPWR sky130_fd_sc_hd__decap_3
X_1131_ _1131_/A _1131_/B VGND VGND VPWR VPWR _1133_/B sky130_fd_sc_hd__nand2_2
X_1062_ _1117_/A _1062_/B _1062_/C VGND VGND VPWR VPWR _1276_/D sky130_fd_sc_hd__nor3_2
XFILLER_33_276 VGND VGND VPWR VPWR sky130_fd_sc_hd__decap_3
X_0915_ _0894_/Y _0895_/Y _0808_/Y VGND VGND VPWR VPWR _0915_/X sky130_fd_sc_hd__a21o_2
X_0846_ _0846_/A _0922_/B VGND VGND VPWR VPWR _0847_/C sky130_fd_sc_hd__nor2_2
X_0777_ _0777_/A VGND VGND VPWR VPWR _0922_/B sky130_fd_sc_hd__buf_2
XFILLER_17_69 VGND VGND VPWR VPWR sky130_fd_sc_hd__fill_1
XFILLER_24_221 VGND VGND VPWR VPWR sky130_fd_sc_hd__fill_2
XFILLER_33_46 VGND VGND VPWR VPWR sky130_fd_sc_hd__decap_3
XFILLER_33_57 VGND VGND VPWR VPWR sky130_fd_sc_hd__decap_3
XPHY_EDGE_ROW_42_Left_91 VGND VGND VPWR VPWR sky130_fd_sc_hd__decap_3
XFILLER_15_221 VGND VGND VPWR VPWR sky130_fd_sc_hd__decap_3
XFILLER_15_265 VGND VGND VPWR VPWR sky130_fd_sc_hd__decap_3
XFILLER_30_213 VGND VGND VPWR VPWR sky130_fd_sc_hd__decap_3
XFILLER_30_268 VGND VGND VPWR VPWR sky130_fd_sc_hd__decap_3
X_0700_ _0699_/Y _0672_/X _1117_/A VGND VGND VPWR VPWR _0700_/Y sky130_fd_sc_hd__a21oi_2
X_0631_ _1290_/Q VGND VGND VPWR VPWR _0811_/B sky130_fd_sc_hd__buf_12
XFILLER_24_3 VGND VGND VPWR VPWR sky130_fd_sc_hd__decap_3
X_1114_ _1059_/Y _1014_/X _1113_/Y VGND VGND VPWR VPWR _1115_/C sky130_fd_sc_hd__a21oi_4
XTAP_TAPCELL_ROW_48_352 VGND VPWR sky130_fd_sc_hd__tapvpwrvgnd_1
XTAP_TAPCELL_ROW_0_106 VGND VPWR sky130_fd_sc_hd__tapvpwrvgnd_1
X_1045_ _1046_/B _1046_/C _1046_/A VGND VGND VPWR VPWR _1049_/B sky130_fd_sc_hd__a21o_2
XTAP_TAPCELL_ROW_23_219 VGND VPWR sky130_fd_sc_hd__tapvpwrvgnd_1
X_0829_ _0829_/A1 _0829_/A2 _0829_/B1 VGND VGND VPWR VPWR _0829_/Y sky130_fd_sc_hd__o21ai_4
XFILLER_9_70 VGND VGND VPWR VPWR sky130_fd_sc_hd__decap_3
XFILLER_28_57 VGND VGND VPWR VPWR sky130_fd_sc_hd__decap_3
XFILLER_44_12 VGND VGND VPWR VPWR sky130_fd_sc_hd__decap_3
XFILLER_12_224 VGND VGND VPWR VPWR sky130_fd_sc_hd__decap_3
XFILLER_44_45 VGND VGND VPWR VPWR sky130_fd_sc_hd__decap_3
XFILLER_44_78 VGND VGND VPWR VPWR sky130_fd_sc_hd__decap_3
XFILLER_8_206 VGND VGND VPWR VPWR sky130_fd_sc_hd__decap_3
XFILLER_47_110 VGND VGND VPWR VPWR sky130_fd_sc_hd__fill_2
XFILLER_47_187 VGND VGND VPWR VPWR sky130_fd_sc_hd__decap_3
XFILLER_7_261 VGND VGND VPWR VPWR sky130_fd_sc_hd__decap_3
XPHY_EDGE_ROW_7_Right_7 VGND VGND VPWR VPWR sky130_fd_sc_hd__decap_3
XFILLER_14_59 VGND VGND VPWR VPWR sky130_fd_sc_hd__fill_2
X_1028_ _0814_/A _1119_/D _1029_/A VGND VGND VPWR VPWR _1028_/Y sky130_fd_sc_hd__a21oi_2
XFILLER_39_12 VGND VGND VPWR VPWR sky130_fd_sc_hd__fill_2
XFILLER_29_165 VGND VGND VPWR VPWR sky130_fd_sc_hd__decap_3
XFILLER_29_198 VGND VGND VPWR VPWR sky130_fd_sc_hd__decap_3
XTAP_TAPCELL_ROW_42_314 VGND VPWR sky130_fd_sc_hd__tapvpwrvgnd_1
XFILLER_20_91 VGND VGND VPWR VPWR sky130_fd_sc_hd__decap_3
XFILLER_35_113 VGND VGND VPWR VPWR sky130_fd_sc_hd__decap_3
XFILLER_6_82 VGND VGND VPWR VPWR sky130_fd_sc_hd__fill_2
XFILLER_25_69 VGND VGND VPWR VPWR sky130_fd_sc_hd__decap_3
XFILLER_41_116 VGND VGND VPWR VPWR sky130_fd_sc_hd__decap_3
Xrebuffer98 _0819_/A VGND VGND VPWR VPWR _0917_/A1 sky130_fd_sc_hd__buf_4
Xrebuffer87 _0659_/Y VGND VGND VPWR VPWR _0660_/D sky130_fd_sc_hd__buf_2
Xrebuffer76 _0872_/Y VGND VGND VPWR VPWR _1056_/B2 sky130_fd_sc_hd__buf_2
XFILLER_34_190 VGND VGND VPWR VPWR sky130_fd_sc_hd__decap_3
XFILLER_41_46 VGND VGND VPWR VPWR sky130_fd_sc_hd__decap_3
XFILLER_41_57 VGND VGND VPWR VPWR sky130_fd_sc_hd__fill_1
Xrebuffer144 _0720_/X VGND VGND VPWR VPWR _0765_/B sky130_fd_sc_hd__buf_2
Xrebuffer122 _0899_/B VGND VGND VPWR VPWR _1020_/A sky130_fd_sc_hd__buf_2
Xrebuffer111 _0899_/B VGND VGND VPWR VPWR _1023_/D sky130_fd_sc_hd__buf_2
Xrebuffer100 _1289_/Q VGND VGND VPWR VPWR output25/A sky130_fd_sc_hd__buf_2
XFILLER_1_234 VGND VGND VPWR VPWR sky130_fd_sc_hd__decap_3
XFILLER_1_256 VGND VGND VPWR VPWR sky130_fd_sc_hd__decap_3
Xrebuffer166 _1165_/Y VGND VGND VPWR VPWR _1247_/C sky130_fd_sc_hd__buf_2
XFILLER_17_113 VGND VGND VPWR VPWR sky130_fd_sc_hd__decap_3
XFILLER_2_29 VGND VGND VPWR VPWR sky130_fd_sc_hd__fill_1
XFILLER_15_91 VGND VGND VPWR VPWR sky130_fd_sc_hd__fill_1
XFILLER_32_127 VGND VGND VPWR VPWR sky130_fd_sc_hd__decap_3
XFILLER_31_90 VGND VGND VPWR VPWR sky130_fd_sc_hd__decap_3
XFILLER_40_193 VGND VGND VPWR VPWR sky130_fd_sc_hd__decap_3
X_1293_ clkload3/A _1293_/D wire72/X VGND VGND VPWR VPWR _1293_/Q sky130_fd_sc_hd__dfrtp_2
XFILLER_23_116 VGND VGND VPWR VPWR sky130_fd_sc_hd__decap_3
XFILLER_48_271 VGND VGND VPWR VPWR sky130_fd_sc_hd__decap_3
XFILLER_23_149 VGND VGND VPWR VPWR sky130_fd_sc_hd__decap_3
XTAP_TAPCELL_ROW_18_196 VGND VPWR sky130_fd_sc_hd__tapvpwrvgnd_1
XFILLER_36_35 VGND VGND VPWR VPWR sky130_fd_sc_hd__decap_3
XFILLER_39_260 VGND VGND VPWR VPWR sky130_fd_sc_hd__decap_3
XFILLER_36_68 VGND VGND VPWR VPWR sky130_fd_sc_hd__decap_3
XFILLER_22_182 VGND VGND VPWR VPWR sky130_fd_sc_hd__decap_3
XFILLER_45_252 VGND VGND VPWR VPWR sky130_fd_sc_hd__decap_3
X_0931_ _0854_/A _0854_/B _0844_/A _0839_/Y VGND VGND VPWR VPWR _0931_/Y sky130_fd_sc_hd__a22oi_2
X_0862_ _0856_/Y _0855_/Y _0847_/Y VGND VGND VPWR VPWR _0864_/A sky130_fd_sc_hd__o21ai_4
XFILLER_9_175 VGND VGND VPWR VPWR sky130_fd_sc_hd__decap_3
XFILLER_9_164 VGND VGND VPWR VPWR sky130_fd_sc_hd__decap_3
XFILLER_9_131 VGND VGND VPWR VPWR sky130_fd_sc_hd__decap_3
X_0793_ _0790_/Y _0792_/Y _0785_/Y _0787_/Y VGND VGND VPWR VPWR _0793_/X sky130_fd_sc_hd__o211a_4
X_1276_ clkload2/A _1276_/D fanout70/X VGND VGND VPWR VPWR _1276_/Q sky130_fd_sc_hd__dfrtp_2
XFILLER_36_230 VGND VGND VPWR VPWR sky130_fd_sc_hd__decap_3
XFILLER_36_274 VGND VGND VPWR VPWR sky130_fd_sc_hd__decap_3
XFILLER_22_59 VGND VGND VPWR VPWR sky130_fd_sc_hd__fill_1
XTAP_TAPCELL_ROW_6_134 VGND VPWR sky130_fd_sc_hd__tapvpwrvgnd_1
XFILLER_27_252 VGND VGND VPWR VPWR sky130_fd_sc_hd__decap_3
XFILLER_47_78 VGND VGND VPWR VPWR sky130_fd_sc_hd__decap_3
XFILLER_10_141 VGND VGND VPWR VPWR sky130_fd_sc_hd__decap_3
XFILLER_10_152 VGND VGND VPWR VPWR sky130_fd_sc_hd__fill_1
XFILLER_42_244 VGND VGND VPWR VPWR sky130_fd_sc_hd__decap_3
XFILLER_42_277 VGND VGND VPWR VPWR sky130_fd_sc_hd__decap_3
XTAP_TAPCELL_ROW_37_291 VGND VPWR sky130_fd_sc_hd__tapvpwrvgnd_1
XFILLER_6_101 VGND VGND VPWR VPWR sky130_fd_sc_hd__decap_3
XFILLER_10_163 VGND VGND VPWR VPWR sky130_fd_sc_hd__decap_3
XFILLER_6_156 VGND VGND VPWR VPWR sky130_fd_sc_hd__decap_3
XFILLER_19_6 VGND VGND VPWR VPWR sky130_fd_sc_hd__decap_3
X_1130_ _1129_/Y _1125_/Y _1111_/B _1111_/A VGND VGND VPWR VPWR _1131_/B sky130_fd_sc_hd__o22a_2
XFILLER_18_285 VGND VGND VPWR VPWR sky130_fd_sc_hd__fill_1
X_1061_ _1014_/X _1059_/Y _1093_/A _1093_/C VGND VGND VPWR VPWR _1062_/C sky130_fd_sc_hd__a211oi_2
X_0914_ _0990_/B _0921_/B _0990_/A VGND VGND VPWR VPWR _0914_/Y sky130_fd_sc_hd__a21boi_4
X_0845_ _0828_/Y _0835_/Y _0839_/Y _0849_/B VGND VGND VPWR VPWR _0847_/A sky130_fd_sc_hd__o211ai_4
X_0776_ _1295_/Q VGND VGND VPWR VPWR _0777_/A sky130_fd_sc_hd__inv_2
XFILLER_17_37 VGND VGND VPWR VPWR sky130_fd_sc_hd__decap_3
XFILLER_24_200 VGND VGND VPWR VPWR sky130_fd_sc_hd__decap_3
X_1259_ clkload1/A _1259_/D fanout69/X VGND VGND VPWR VPWR _1259_/Q sky130_fd_sc_hd__dfrtp_2
XFILLER_33_14 VGND VGND VPWR VPWR sky130_fd_sc_hd__decap_3
XFILLER_33_25 VGND VGND VPWR VPWR sky130_fd_sc_hd__decap_3
XFILLER_15_244 VGND VGND VPWR VPWR sky130_fd_sc_hd__fill_1
XFILLER_15_277 VGND VGND VPWR VPWR sky130_fd_sc_hd__decap_3
XFILLER_30_236 VGND VGND VPWR VPWR sky130_fd_sc_hd__decap_3
X_0630_ _0630_/A VGND VGND VPWR VPWR _1140_/A sky130_fd_sc_hd__buf_2
XFILLER_17_3 VGND VGND VPWR VPWR sky130_fd_sc_hd__decap_3
X_1113_ _1063_/Y _1064_/Y _1112_/Y VGND VGND VPWR VPWR _1113_/Y sky130_fd_sc_hd__o21ai_2
X_1044_ _1044_/A _1297_/Q VGND VGND VPWR VPWR _1046_/A sky130_fd_sc_hd__nand2_2
XTAP_TAPCELL_ROW_0_107 VGND VPWR sky130_fd_sc_hd__tapvpwrvgnd_1
XFILLER_21_225 VGND VGND VPWR VPWR sky130_fd_sc_hd__decap_3
X_0828_ _0819_/Y _0826_/Y _0836_/A VGND VGND VPWR VPWR _0828_/Y sky130_fd_sc_hd__a21oi_4
X_0759_ _0759_/A _0922_/A VGND VGND VPWR VPWR _0760_/C sky130_fd_sc_hd__nor2_2
XFILLER_28_14 VGND VGND VPWR VPWR sky130_fd_sc_hd__fill_2
XFILLER_44_57 VGND VGND VPWR VPWR sky130_fd_sc_hd__fill_2
XFILLER_47_155 VGND VGND VPWR VPWR sky130_fd_sc_hd__decap_3
XFILLER_18_91 VGND VGND VPWR VPWR sky130_fd_sc_hd__decap_3
XFILLER_7_284 VGND VGND VPWR VPWR sky130_fd_sc_hd__fill_2
XFILLER_7_240 VGND VGND VPWR VPWR sky130_fd_sc_hd__decap_3
XFILLER_38_100 VGND VGND VPWR VPWR sky130_fd_sc_hd__fill_1
XFILLER_38_133 VGND VGND VPWR VPWR sky130_fd_sc_hd__decap_3
XFILLER_38_144 VGND VGND VPWR VPWR sky130_fd_sc_hd__fill_1
XFILLER_38_188 VGND VGND VPWR VPWR sky130_fd_sc_hd__decap_3
Xclkbuf_3_5__f_clk clkbuf_0_clk/X VGND VGND VPWR VPWR clkload3/A sky130_fd_sc_hd__clkbuf_16
X_1027_ _1027_/A _1070_/A VGND VGND VPWR VPWR _1029_/A sky130_fd_sc_hd__nand2_2
XFILLER_30_15 VGND VGND VPWR VPWR sky130_fd_sc_hd__decap_3
XFILLER_30_48 VGND VGND VPWR VPWR sky130_fd_sc_hd__fill_2
XFILLER_29_144 VGND VGND VPWR VPWR sky130_fd_sc_hd__decap_3
XTAP_TAPCELL_ROW_42_315 VGND VPWR sky130_fd_sc_hd__tapvpwrvgnd_1
XFILLER_20_81 VGND VGND VPWR VPWR sky130_fd_sc_hd__decap_3
XFILLER_35_136 VGND VGND VPWR VPWR sky130_fd_sc_hd__fill_2
XFILLER_25_15 VGND VGND VPWR VPWR sky130_fd_sc_hd__fill_1
XFILLER_26_158 VGND VGND VPWR VPWR sky130_fd_sc_hd__decap_3
Xrebuffer99 _1288_/Q VGND VGND VPWR VPWR output24/A sky130_fd_sc_hd__buf_2
Xrebuffer88 _0906_/X VGND VGND VPWR VPWR _0984_/A1 sky130_fd_sc_hd__buf_2
Xrebuffer77 _1010_/A VGND VGND VPWR VPWR _0941_/A sky130_fd_sc_hd__buf_2
Xrebuffer145 _0711_/Y VGND VGND VPWR VPWR _0712_/A sky130_fd_sc_hd__buf_2
Xrebuffer123 _0866_/Y VGND VGND VPWR VPWR _0879_/B sky130_fd_sc_hd__buf_2
Xrebuffer112 _0899_/B VGND VGND VPWR VPWR _0808_/A1 sky130_fd_sc_hd__buf_2
Xrebuffer101 _1290_/Q VGND VGND VPWR VPWR output26/A sky130_fd_sc_hd__buf_2
XFILLER_1_202 VGND VGND VPWR VPWR sky130_fd_sc_hd__fill_1
XFILLER_17_125 VGND VGND VPWR VPWR sky130_fd_sc_hd__decap_3
XFILLER_25_180 VGND VGND VPWR VPWR sky130_fd_sc_hd__fill_2
XFILLER_32_106 VGND VGND VPWR VPWR sky130_fd_sc_hd__decap_3
XFILLER_40_161 VGND VGND VPWR VPWR sky130_fd_sc_hd__decap_3
X_1292_ clkload3/A _1292_/D wire72/X VGND VGND VPWR VPWR _1292_/Q sky130_fd_sc_hd__dfrtp_2
XFILLER_48_250 VGND VGND VPWR VPWR sky130_fd_sc_hd__fill_2
XFILLER_16_191 VGND VGND VPWR VPWR sky130_fd_sc_hd__decap_3
XFILLER_23_106 VGND VGND VPWR VPWR sky130_fd_sc_hd__fill_2
XTAP_TAPCELL_ROW_18_197 VGND VPWR sky130_fd_sc_hd__tapvpwrvgnd_1
XFILLER_31_172 VGND VGND VPWR VPWR sky130_fd_sc_hd__decap_3
XFILLER_31_183 VGND VGND VPWR VPWR sky130_fd_sc_hd__decap_3
XFILLER_36_25 VGND VGND VPWR VPWR sky130_fd_sc_hd__decap_3
XFILLER_36_47 VGND VGND VPWR VPWR sky130_fd_sc_hd__decap_3
XFILLER_39_272 VGND VGND VPWR VPWR sky130_fd_sc_hd__decap_3
XFILLER_46_209 VGND VGND VPWR VPWR sky130_fd_sc_hd__decap_3
XFILLER_22_161 VGND VGND VPWR VPWR sky130_fd_sc_hd__decap_3
XFILLER_45_220 VGND VGND VPWR VPWR sky130_fd_sc_hd__decap_3
XFILLER_45_231 VGND VGND VPWR VPWR sky130_fd_sc_hd__decap_3
XFILLER_45_264 VGND VGND VPWR VPWR sky130_fd_sc_hd__decap_3
XFILLER_13_172 VGND VGND VPWR VPWR sky130_fd_sc_hd__fill_2
XFILLER_13_183 VGND VGND VPWR VPWR sky130_fd_sc_hd__decap_3
X_0930_ _1002_/A _0930_/B VGND VGND VPWR VPWR _0933_/B sky130_fd_sc_hd__and2_2
X_0861_ _0940_/A _0930_/B VGND VGND VPWR VPWR _0866_/C sky130_fd_sc_hd__nand2_2
X_0792_ _0792_/A _0792_/B VGND VGND VPWR VPWR _0792_/Y sky130_fd_sc_hd__nand2_2
XTAP_TAPCELL_ROW_15_178 VGND VPWR sky130_fd_sc_hd__tapvpwrvgnd_1
XFILLER_9_143 VGND VGND VPWR VPWR sky130_fd_sc_hd__fill_2
XFILLER_28_209 VGND VGND VPWR VPWR sky130_fd_sc_hd__decap_3
XFILLER_36_253 VGND VGND VPWR VPWR sky130_fd_sc_hd__decap_3
X_1275_ clkload1/A _1275_/D fanout70/X VGND VGND VPWR VPWR _1275_/Q sky130_fd_sc_hd__dfrtp_2
Xwire68 wire68/A VGND VGND VPWR VPWR wire68/X sky130_fd_sc_hd__clkbuf_4
XFILLER_47_24 VGND VGND VPWR VPWR sky130_fd_sc_hd__fill_2
XTAP_TAPCELL_ROW_6_135 VGND VPWR sky130_fd_sc_hd__tapvpwrvgnd_1
XFILLER_42_223 VGND VGND VPWR VPWR sky130_fd_sc_hd__decap_3
XFILLER_47_57 VGND VGND VPWR VPWR sky130_fd_sc_hd__decap_3
XTAP_TAPCELL_ROW_37_292 VGND VPWR sky130_fd_sc_hd__tapvpwrvgnd_1
XTAP_TAPCELL_ROW_29_248 VGND VPWR sky130_fd_sc_hd__tapvpwrvgnd_1
XPHY_EDGE_ROW_29_Right_29 VGND VGND VPWR VPWR sky130_fd_sc_hd__decap_3
XFILLER_42_256 VGND VGND VPWR VPWR sky130_fd_sc_hd__decap_3
XPHY_EDGE_ROW_38_Right_38 VGND VGND VPWR VPWR sky130_fd_sc_hd__decap_3
XFILLER_8_29 VGND VGND VPWR VPWR sky130_fd_sc_hd__decap_3
XFILLER_10_197 VGND VGND VPWR VPWR sky130_fd_sc_hd__decap_3
XFILLER_12_71 VGND VGND VPWR VPWR sky130_fd_sc_hd__fill_2
XFILLER_6_168 VGND VGND VPWR VPWR sky130_fd_sc_hd__fill_1
XFILLER_18_242 VGND VGND VPWR VPWR sky130_fd_sc_hd__decap_3
X_1060_ _1017_/X _1011_/Y _1093_/A _1093_/C _1060_/C1 VGND VGND VPWR VPWR _1062_/B
+ sky130_fd_sc_hd__o221a_2
XPHY_EDGE_ROW_47_Right_47 VGND VGND VPWR VPWR sky130_fd_sc_hd__decap_3
XFILLER_18_264 VGND VGND VPWR VPWR sky130_fd_sc_hd__decap_3
XFILLER_33_267 VGND VGND VPWR VPWR sky130_fd_sc_hd__decap_3
X_0913_ _0832_/Y _0913_/A2_N _0836_/A _0819_/Y VGND VGND VPWR VPWR _0990_/A sky130_fd_sc_hd__a2bb2oi_4
X_0844_ _0844_/A VGND VGND VPWR VPWR _0849_/B sky130_fd_sc_hd__inv_2
X_0775_ _0768_/Y _0769_/X _0783_/B VGND VGND VPWR VPWR _0803_/A sky130_fd_sc_hd__o21ai_2
XFILLER_17_49 VGND VGND VPWR VPWR sky130_fd_sc_hd__decap_3
XFILLER_24_212 VGND VGND VPWR VPWR sky130_fd_sc_hd__decap_3
X_1189_ _1305_/Q _1273_/Q _1174_/B _1180_/A _1171_/Y VGND VGND VPWR VPWR _1199_/B
+ sky130_fd_sc_hd__o2111ai_4
X_1258_ clkload1/A _1258_/D wire68/A VGND VGND VPWR VPWR _1258_/Q sky130_fd_sc_hd__dfrtp_2
XFILLER_24_256 VGND VGND VPWR VPWR sky130_fd_sc_hd__decap_3
XFILLER_24_278 VGND VGND VPWR VPWR sky130_fd_sc_hd__decap_3
XTAP_TAPCELL_ROW_34_273 VGND VPWR sky130_fd_sc_hd__tapvpwrvgnd_1
XFILLER_15_212 VGND VGND VPWR VPWR sky130_fd_sc_hd__decap_3
XFILLER_15_256 VGND VGND VPWR VPWR sky130_fd_sc_hd__decap_3
XFILLER_23_81 VGND VGND VPWR VPWR sky130_fd_sc_hd__fill_2
XFILLER_23_92 VGND VGND VPWR VPWR sky130_fd_sc_hd__decap_3
XFILLER_30_248 VGND VGND VPWR VPWR sky130_fd_sc_hd__decap_3
XPHY_EDGE_ROW_29_Left_78 VGND VGND VPWR VPWR sky130_fd_sc_hd__decap_3
XFILLER_2_182 VGND VGND VPWR VPWR sky130_fd_sc_hd__fill_2
XFILLER_31_6 VGND VGND VPWR VPWR sky130_fd_sc_hd__fill_2
XFILLER_0_85 VGND VGND VPWR VPWR sky130_fd_sc_hd__decap_3
X_1112_ _1063_/Y _1064_/Y _1093_/B VGND VGND VPWR VPWR _1112_/Y sky130_fd_sc_hd__a21oi_2
X_1043_ wire52/X _1082_/B _1042_/C VGND VGND VPWR VPWR _1046_/C sky130_fd_sc_hd__a21o_2
XTAP_TAPCELL_ROW_48_343 VGND VPWR sky130_fd_sc_hd__tapvpwrvgnd_1
XFILLER_9_94 VGND VGND VPWR VPWR sky130_fd_sc_hd__fill_1
XFILLER_9_83 VGND VGND VPWR VPWR sky130_fd_sc_hd__decap_3
X_0827_ _0680_/B _0745_/A _0829_/A2 _0757_/C VGND VGND VPWR VPWR _0836_/A sky130_fd_sc_hd__o31a_4
X_0758_ _1044_/A VGND VGND VPWR VPWR _0922_/A sky130_fd_sc_hd__inv_2
X_0689_ _0689_/A VGND VGND VPWR VPWR _0778_/A sky130_fd_sc_hd__inv_2
XFILLER_47_123 VGND VGND VPWR VPWR sky130_fd_sc_hd__fill_1
XFILLER_47_178 VGND VGND VPWR VPWR sky130_fd_sc_hd__decap_3
XFILLER_11_281 VGND VGND VPWR VPWR sky130_fd_sc_hd__decap_3
XFILLER_7_252 VGND VGND VPWR VPWR sky130_fd_sc_hd__decap_3
XFILLER_7_230 VGND VGND VPWR VPWR sky130_fd_sc_hd__fill_1
XFILLER_14_17 VGND VGND VPWR VPWR sky130_fd_sc_hd__fill_1
X_1026_ _1021_/Y _1022_/X _1023_/Y _1068_/A VGND VGND VPWR VPWR _1075_/A sky130_fd_sc_hd__o211ai_2
XFILLER_30_27 VGND VGND VPWR VPWR sky130_fd_sc_hd__fill_1
XFILLER_29_134 VGND VGND VPWR VPWR sky130_fd_sc_hd__decap_3
XFILLER_29_156 VGND VGND VPWR VPWR sky130_fd_sc_hd__decap_3
XFILLER_29_189 VGND VGND VPWR VPWR sky130_fd_sc_hd__decap_3
XFILLER_44_148 VGND VGND VPWR VPWR sky130_fd_sc_hd__decap_3
XTAP_TAPCELL_ROW_42_316 VGND VPWR sky130_fd_sc_hd__tapvpwrvgnd_1
XFILLER_6_95 VGND VGND VPWR VPWR sky130_fd_sc_hd__decap_3
XFILLER_6_73 VGND VGND VPWR VPWR sky130_fd_sc_hd__decap_3
XFILLER_26_137 VGND VGND VPWR VPWR sky130_fd_sc_hd__decap_3
XPHY_EDGE_ROW_16_Left_65 VGND VGND VPWR VPWR sky130_fd_sc_hd__decap_3
XFILLER_25_38 VGND VGND VPWR VPWR sky130_fd_sc_hd__fill_1
XFILLER_34_181 VGND VGND VPWR VPWR sky130_fd_sc_hd__decap_3
Xrebuffer89 _1059_/Y VGND VGND VPWR VPWR _1060_/C1 sky130_fd_sc_hd__buf_2
Xrebuffer78 _1010_/A VGND VGND VPWR VPWR _1054_/A1 sky130_fd_sc_hd__buf_2
X_1009_ _1009_/A _1018_/A VGND VGND VPWR VPWR _1011_/A sky130_fd_sc_hd__nand2_2
Xrebuffer146 _0713_/Y VGND VGND VPWR VPWR _0829_/A1 sky130_fd_sc_hd__buf_2
Xrebuffer113 _0811_/B VGND VGND VPWR VPWR _0713_/A sky130_fd_sc_hd__buf_2
Xrebuffer102 _0833_/Y VGND VGND VPWR VPWR _0913_/A2_N sky130_fd_sc_hd__buf_4
XFILLER_1_225 VGND VGND VPWR VPWR sky130_fd_sc_hd__decap_3
XFILLER_9_6 VGND VGND VPWR VPWR sky130_fd_sc_hd__decap_3
XFILLER_17_137 VGND VGND VPWR VPWR sky130_fd_sc_hd__decap_3
XFILLER_17_159 VGND VGND VPWR VPWR sky130_fd_sc_hd__decap_3
XFILLER_15_82 VGND VGND VPWR VPWR sky130_fd_sc_hd__decap_3
XFILLER_31_81 VGND VGND VPWR VPWR sky130_fd_sc_hd__decap_3
X_1291_ _1291_/CLK _1291_/D wire72/X VGND VGND VPWR VPWR _1291_/Q sky130_fd_sc_hd__dfrtp_2
XFILLER_48_284 VGND VGND VPWR VPWR sky130_fd_sc_hd__fill_2
XFILLER_48_262 VGND VGND VPWR VPWR sky130_fd_sc_hd__decap_3
XFILLER_36_59 VGND VGND VPWR VPWR sky130_fd_sc_hd__decap_3
XFILLER_39_251 VGND VGND VPWR VPWR sky130_fd_sc_hd__decap_3
XFILLER_39_284 VGND VGND VPWR VPWR sky130_fd_sc_hd__fill_2
XFILLER_22_173 VGND VGND VPWR VPWR sky130_fd_sc_hd__decap_3
XFILLER_13_140 VGND VGND VPWR VPWR sky130_fd_sc_hd__decap_3
XFILLER_26_81 VGND VGND VPWR VPWR sky130_fd_sc_hd__decap_3
XFILLER_26_92 VGND VGND VPWR VPWR sky130_fd_sc_hd__decap_3
XFILLER_45_243 VGND VGND VPWR VPWR sky130_fd_sc_hd__decap_3
XFILLER_45_276 VGND VGND VPWR VPWR sky130_fd_sc_hd__decap_3
X_0860_ _0873_/B _0873_/C _0873_/A VGND VGND VPWR VPWR _0879_/A sky130_fd_sc_hd__o21ai_2
X_0791_ _0768_/Y _0769_/X _0783_/B _0783_/A VGND VGND VPWR VPWR _0792_/A sky130_fd_sc_hd__o211ai_2
XTAP_TAPCELL_ROW_15_179 VGND VPWR sky130_fd_sc_hd__tapvpwrvgnd_1
XFILLER_9_111 VGND VGND VPWR VPWR sky130_fd_sc_hd__fill_1
XFILLER_36_221 VGND VGND VPWR VPWR sky130_fd_sc_hd__decap_3
XFILLER_36_265 VGND VGND VPWR VPWR sky130_fd_sc_hd__decap_3
X_1274_ clkload2/A _1274_/D fanout70/X VGND VGND VPWR VPWR _1274_/Q sky130_fd_sc_hd__dfrtp_2
XFILLER_22_39 VGND VGND VPWR VPWR sky130_fd_sc_hd__decap_3
X_0989_ _1044_/A _1036_/D VGND VGND VPWR VPWR _0993_/B sky130_fd_sc_hd__nand2_2
XFILLER_47_47 VGND VGND VPWR VPWR sky130_fd_sc_hd__decap_3
XFILLER_47_69 VGND VGND VPWR VPWR sky130_fd_sc_hd__decap_3
XTAP_TAPCELL_ROW_6_136 VGND VPWR sky130_fd_sc_hd__tapvpwrvgnd_1
XFILLER_27_243 VGND VGND VPWR VPWR sky130_fd_sc_hd__decap_3
XFILLER_42_235 VGND VGND VPWR VPWR sky130_fd_sc_hd__decap_3
XFILLER_42_268 VGND VGND VPWR VPWR sky130_fd_sc_hd__decap_3
XTAP_TAPCELL_ROW_29_249 VGND VPWR sky130_fd_sc_hd__tapvpwrvgnd_1
XFILLER_6_147 VGND VGND VPWR VPWR sky130_fd_sc_hd__decap_3
XFILLER_6_136 VGND VGND VPWR VPWR sky130_fd_sc_hd__decap_3
XFILLER_18_210 VGND VGND VPWR VPWR sky130_fd_sc_hd__decap_3
XFILLER_18_276 VGND VGND VPWR VPWR sky130_fd_sc_hd__decap_3
XFILLER_33_202 VGND VGND VPWR VPWR sky130_fd_sc_hd__decap_3
XFILLER_37_80 VGND VGND VPWR VPWR sky130_fd_sc_hd__decap_3
XFILLER_33_246 VGND VGND VPWR VPWR sky130_fd_sc_hd__fill_1
XFILLER_33_279 VGND VGND VPWR VPWR sky130_fd_sc_hd__fill_1
X_0912_ _0912_/A _0912_/B _0912_/C VGND VGND VPWR VPWR _0921_/B sky130_fd_sc_hd__nand3_4
X_0843_ _0843_/A _0844_/A VGND VGND VPWR VPWR _0847_/B sky130_fd_sc_hd__nand2_4
X_0774_ _0774_/A _0774_/B _0774_/C VGND VGND VPWR VPWR _0783_/B sky130_fd_sc_hd__nand3_4
XTAP_TAPCELL_ROW_11_160 VGND VPWR sky130_fd_sc_hd__tapvpwrvgnd_1
X_1188_ _1257_/Q _1275_/Q _1256_/Q _1274_/Q VGND VGND VPWR VPWR _1190_/C sky130_fd_sc_hd__o211a_2
X_1257_ clkload2/A _1257_/D fanout70/X VGND VGND VPWR VPWR _1257_/Q sky130_fd_sc_hd__dfrtp_2
XFILLER_33_49 VGND VGND VPWR VPWR sky130_fd_sc_hd__decap_3
XTAP_TAPCELL_ROW_34_274 VGND VPWR sky130_fd_sc_hd__tapvpwrvgnd_1
XFILLER_15_268 VGND VGND VPWR VPWR sky130_fd_sc_hd__fill_1
XTAP_TAPCELL_ROW_25_230 VGND VPWR sky130_fd_sc_hd__tapvpwrvgnd_1
XPHY_EDGE_ROW_4_Left_53 VGND VGND VPWR VPWR sky130_fd_sc_hd__decap_3
XFILLER_23_60 VGND VGND VPWR VPWR sky130_fd_sc_hd__decap_3
XFILLER_24_6 VGND VGND VPWR VPWR sky130_fd_sc_hd__decap_3
XFILLER_2_194 VGND VGND VPWR VPWR sky130_fd_sc_hd__fill_2
XFILLER_0_75 VGND VGND VPWR VPWR sky130_fd_sc_hd__fill_1
X_1111_ _1111_/A _1111_/B VGND VGND VPWR VPWR _1127_/B sky130_fd_sc_hd__xor2_2
X_1042_ wire52/X _1082_/B _1042_/C VGND VGND VPWR VPWR _1046_/B sky130_fd_sc_hd__nand3_2
XTAP_TAPCELL_ROW_48_344 VGND VPWR sky130_fd_sc_hd__tapvpwrvgnd_1
XFILLER_9_73 VGND VGND VPWR VPWR sky130_fd_sc_hd__decap_3
XFILLER_9_40 VGND VGND VPWR VPWR sky130_fd_sc_hd__decap_3
X_0826_ _0759_/A _0903_/B _0824_/Y _0825_/Y VGND VGND VPWR VPWR _0826_/Y sky130_fd_sc_hd__o211ai_4
X_0757_ _0713_/Y _0757_/B _0757_/C VGND VGND VPWR VPWR _0760_/B sky130_fd_sc_hd__nand3b_4
X_0688_ _0683_/A _0683_/C _0688_/A3 _0677_/X VGND VGND VPWR VPWR _0688_/X sky130_fd_sc_hd__a31o_2
XTAP_TAPCELL_ROW_39_300 VGND VPWR sky130_fd_sc_hd__tapvpwrvgnd_1
XFILLER_12_227 VGND VGND VPWR VPWR sky130_fd_sc_hd__decap_3
XFILLER_44_15 VGND VGND VPWR VPWR sky130_fd_sc_hd__decap_3
XFILLER_44_48 VGND VGND VPWR VPWR sky130_fd_sc_hd__decap_3
XPHY_EDGE_ROW_46_Left_95 VGND VGND VPWR VPWR sky130_fd_sc_hd__decap_3
XFILLER_8_209 VGND VGND VPWR VPWR sky130_fd_sc_hd__decap_3
XPHY_EDGE_ROW_30_Left_79 VGND VGND VPWR VPWR sky130_fd_sc_hd__decap_3
XFILLER_47_113 VGND VGND VPWR VPWR sky130_fd_sc_hd__decap_3
XFILLER_34_81 VGND VGND VPWR VPWR sky130_fd_sc_hd__decap_3
XFILLER_7_220 VGND VGND VPWR VPWR sky130_fd_sc_hd__decap_3
XFILLER_7_264 VGND VGND VPWR VPWR sky130_fd_sc_hd__decap_3
XFILLER_22_3 VGND VGND VPWR VPWR sky130_fd_sc_hd__decap_3
XFILLER_14_29 VGND VGND VPWR VPWR sky130_fd_sc_hd__decap_3
XFILLER_46_190 VGND VGND VPWR VPWR sky130_fd_sc_hd__decap_3
X_1025_ _1024_/Y _0890_/B _0964_/Y VGND VGND VPWR VPWR _1068_/A sky130_fd_sc_hd__a21o_2
X_0809_ _0811_/B _1289_/Q VGND VGND VPWR VPWR _0810_/A sky130_fd_sc_hd__nand2_2
XFILLER_29_113 VGND VGND VPWR VPWR sky130_fd_sc_hd__decap_3
XTAP_TAPCELL_ROW_42_317 VGND VPWR sky130_fd_sc_hd__tapvpwrvgnd_1
XFILLER_20_72 VGND VGND VPWR VPWR sky130_fd_sc_hd__decap_3
XFILLER_20_94 VGND VGND VPWR VPWR sky130_fd_sc_hd__decap_3
XFILLER_29_92 VGND VGND VPWR VPWR sky130_fd_sc_hd__fill_1
XFILLER_35_105 VGND VGND VPWR VPWR sky130_fd_sc_hd__decap_3
XFILLER_35_116 VGND VGND VPWR VPWR sky130_fd_sc_hd__decap_3
XFILLER_6_85 VGND VGND VPWR VPWR sky130_fd_sc_hd__fill_1
Xrebuffer79 _1127_/B VGND VGND VPWR VPWR _1115_/B sky130_fd_sc_hd__buf_2
XFILLER_34_193 VGND VGND VPWR VPWR sky130_fd_sc_hd__decap_3
XFILLER_41_108 VGND VGND VPWR VPWR sky130_fd_sc_hd__decap_3
XFILLER_41_119 VGND VGND VPWR VPWR sky130_fd_sc_hd__fill_2
Xrebuffer103 _0843_/A VGND VGND VPWR VPWR _0849_/A sky130_fd_sc_hd__buf_2
X_1008_ _1010_/A _1010_/D VGND VGND VPWR VPWR _1018_/A sky130_fd_sc_hd__nand2_2
XFILLER_41_49 VGND VGND VPWR VPWR sky130_fd_sc_hd__fill_2
Xrebuffer158 _1161_/Y VGND VGND VPWR VPWR _1242_/C sky130_fd_sc_hd__buf_2
Xrebuffer147 _0713_/Y VGND VGND VPWR VPWR _0756_/B1 sky130_fd_sc_hd__buf_2
Xrebuffer125 _0757_/C VGND VGND VPWR VPWR _0829_/B1 sky130_fd_sc_hd__buf_4
Xrebuffer114 _0857_/X VGND VGND VPWR VPWR _0934_/B2 sky130_fd_sc_hd__buf_4
XFILLER_1_237 VGND VGND VPWR VPWR sky130_fd_sc_hd__fill_1
XFILLER_1_259 VGND VGND VPWR VPWR sky130_fd_sc_hd__decap_3
XFILLER_17_116 VGND VGND VPWR VPWR sky130_fd_sc_hd__decap_3
XFILLER_31_60 VGND VGND VPWR VPWR sky130_fd_sc_hd__decap_3
XFILLER_40_185 VGND VGND VPWR VPWR sky130_fd_sc_hd__decap_3
XFILLER_31_93 VGND VGND VPWR VPWR sky130_fd_sc_hd__decap_3
XPHY_EDGE_ROW_33_Left_82 VGND VGND VPWR VPWR sky130_fd_sc_hd__decap_3
XFILLER_0_270 VGND VGND VPWR VPWR sky130_fd_sc_hd__fill_1
XFILLER_0_281 VGND VGND VPWR VPWR sky130_fd_sc_hd__decap_3
X_1290_ clkload3/A input9/X wire72/X VGND VGND VPWR VPWR _1290_/Q sky130_fd_sc_hd__dfrtp_2
XFILLER_48_274 VGND VGND VPWR VPWR sky130_fd_sc_hd__decap_3
XFILLER_16_182 VGND VGND VPWR VPWR sky130_fd_sc_hd__decap_3
XFILLER_23_119 VGND VGND VPWR VPWR sky130_fd_sc_hd__decap_3
XFILLER_36_38 VGND VGND VPWR VPWR sky130_fd_sc_hd__decap_3
XFILLER_39_263 VGND VGND VPWR VPWR sky130_fd_sc_hd__decap_3
XFILLER_22_130 VGND VGND VPWR VPWR sky130_fd_sc_hd__decap_3
XFILLER_22_141 VGND VGND VPWR VPWR sky130_fd_sc_hd__fill_1
XFILLER_22_185 VGND VGND VPWR VPWR sky130_fd_sc_hd__decap_3
XFILLER_13_152 VGND VGND VPWR VPWR sky130_fd_sc_hd__decap_3
XFILLER_45_255 VGND VGND VPWR VPWR sky130_fd_sc_hd__decap_3
XFILLER_42_81 VGND VGND VPWR VPWR sky130_fd_sc_hd__decap_3
X_0790_ _0783_/A _0783_/B _0789_/X VGND VGND VPWR VPWR _0790_/Y sky130_fd_sc_hd__a21oi_2
XFILLER_9_178 VGND VGND VPWR VPWR sky130_fd_sc_hd__decap_3
XFILLER_9_167 VGND VGND VPWR VPWR sky130_fd_sc_hd__fill_1
X_1273_ clkload2/A _1273_/D fanout70/X VGND VGND VPWR VPWR _1273_/Q sky130_fd_sc_hd__dfrtp_2
XFILLER_36_233 VGND VGND VPWR VPWR sky130_fd_sc_hd__fill_1
XFILLER_36_277 VGND VGND VPWR VPWR sky130_fd_sc_hd__decap_3
X_0988_ _0988_/A _0988_/B _1044_/A _1036_/D VGND VGND VPWR VPWR _1047_/A sky130_fd_sc_hd__nand4_4
XTAP_TAPCELL_ROW_6_137 VGND VPWR sky130_fd_sc_hd__tapvpwrvgnd_1
XFILLER_27_255 VGND VGND VPWR VPWR sky130_fd_sc_hd__fill_2
XFILLER_42_214 VGND VGND VPWR VPWR sky130_fd_sc_hd__decap_3
XFILLER_42_247 VGND VGND VPWR VPWR sky130_fd_sc_hd__decap_3
XFILLER_10_166 VGND VGND VPWR VPWR sky130_fd_sc_hd__fill_1
XFILLER_6_159 VGND VGND VPWR VPWR sky130_fd_sc_hd__decap_3
XFILLER_6_104 VGND VGND VPWR VPWR sky130_fd_sc_hd__decap_3
XFILLER_18_200 VGND VGND VPWR VPWR sky130_fd_sc_hd__fill_1
XFILLER_18_233 VGND VGND VPWR VPWR sky130_fd_sc_hd__decap_3
XFILLER_19_9 VGND VGND VPWR VPWR sky130_fd_sc_hd__decap_3
X_0911_ _0978_/A _0973_/A _0973_/B VGND VGND VPWR VPWR _0912_/A sky130_fd_sc_hd__nand3_2
X_0842_ _0755_/A _0755_/B _0755_/C _0841_/Y _0771_/B VGND VGND VPWR VPWR _0844_/A
+ sky130_fd_sc_hd__a32o_2
X_0773_ _0773_/A1 _0773_/A2 _0712_/Y _0771_/A _0771_/B VGND VGND VPWR VPWR _0774_/C
+ sky130_fd_sc_hd__o2111ai_2
XTAP_TAPCELL_ROW_11_161 VGND VPWR sky130_fd_sc_hd__tapvpwrvgnd_1
X_1256_ clkload0/A _1256_/D wire68/X VGND VGND VPWR VPWR _1256_/Q sky130_fd_sc_hd__dfrtp_2
XTAP_TAPCELL_ROW_3_118 VGND VPWR sky130_fd_sc_hd__tapvpwrvgnd_1
XFILLER_24_203 VGND VGND VPWR VPWR sky130_fd_sc_hd__decap_3
XFILLER_24_247 VGND VGND VPWR VPWR sky130_fd_sc_hd__decap_3
XFILLER_33_17 VGND VGND VPWR VPWR sky130_fd_sc_hd__decap_3
X_1187_ _1187_/A _1187_/B VGND VGND VPWR VPWR _1200_/A sky130_fd_sc_hd__nor2_2
XTAP_TAPCELL_ROW_34_275 VGND VPWR sky130_fd_sc_hd__tapvpwrvgnd_1
XFILLER_32_280 VGND VGND VPWR VPWR sky130_fd_sc_hd__decap_3
XFILLER_15_225 VGND VGND VPWR VPWR sky130_fd_sc_hd__decap_3
XFILLER_30_239 VGND VGND VPWR VPWR sky130_fd_sc_hd__decap_3
XTAP_TAPCELL_ROW_25_231 VGND VPWR sky130_fd_sc_hd__tapvpwrvgnd_1
XFILLER_17_6 VGND VGND VPWR VPWR sky130_fd_sc_hd__decap_3
XFILLER_2_151 VGND VGND VPWR VPWR sky130_fd_sc_hd__decap_3
X_1110_ _1081_/C _1119_/C _1081_/D _1081_/A _1109_/Y VGND VGND VPWR VPWR _1111_/B
+ sky130_fd_sc_hd__a41oi_2
XFILLER_48_91 VGND VGND VPWR VPWR sky130_fd_sc_hd__decap_3
XFILLER_21_228 VGND VGND VPWR VPWR sky130_fd_sc_hd__fill_2
X_1041_ _1083_/A _1082_/C VGND VGND VPWR VPWR _1042_/C sky130_fd_sc_hd__nand2_2
XTAP_TAPCELL_ROW_48_345 VGND VPWR sky130_fd_sc_hd__tapvpwrvgnd_1
X_0825_ _0817_/X _0813_/Y _0746_/Y VGND VGND VPWR VPWR _0825_/Y sky130_fd_sc_hd__o21bai_2
X_0756_ _0750_/X _0756_/A2 _0756_/B1 VGND VGND VPWR VPWR _0760_/A sky130_fd_sc_hd__o21ai_2
X_0687_ _0687_/A _0687_/B VGND VGND VPWR VPWR _0697_/A sky130_fd_sc_hd__nor2_2
X_1239_ _1160_/Y _1159_/X _1240_/A2 VGND VGND VPWR VPWR _1239_/Y sky130_fd_sc_hd__a21oi_2
XTAP_TAPCELL_ROW_39_301 VGND VPWR sky130_fd_sc_hd__tapvpwrvgnd_1
XFILLER_18_50 VGND VGND VPWR VPWR sky130_fd_sc_hd__decap_3
XFILLER_18_94 VGND VGND VPWR VPWR sky130_fd_sc_hd__decap_3
XFILLER_47_158 VGND VGND VPWR VPWR sky130_fd_sc_hd__fill_1
XFILLER_47_169 VGND VGND VPWR VPWR sky130_fd_sc_hd__decap_3
XFILLER_7_243 VGND VGND VPWR VPWR sky130_fd_sc_hd__decap_3
XFILLER_7_276 VGND VGND VPWR VPWR sky130_fd_sc_hd__decap_3
XFILLER_38_136 VGND VGND VPWR VPWR sky130_fd_sc_hd__decap_3
X_1024_ _1024_/A split/X _1070_/A VGND VGND VPWR VPWR _1024_/Y sky130_fd_sc_hd__nand3_2
XFILLER_30_18 VGND VGND VPWR VPWR sky130_fd_sc_hd__decap_3
XFILLER_30_29 VGND VGND VPWR VPWR sky130_fd_sc_hd__decap_3
X_0808_ _0808_/A1 _0805_/Y _1024_/A _1104_/C _0807_/X VGND VGND VPWR VPWR _0808_/Y
+ sky130_fd_sc_hd__o2111ai_4
XFILLER_29_125 VGND VGND VPWR VPWR sky130_fd_sc_hd__decap_3
X_0739_ _0699_/A _0703_/X _0735_/Y VGND VGND VPWR VPWR _0801_/B sky130_fd_sc_hd__o21ai_2
XFILLER_29_147 VGND VGND VPWR VPWR sky130_fd_sc_hd__decap_3
XFILLER_29_169 VGND VGND VPWR VPWR sky130_fd_sc_hd__fill_2
XFILLER_44_106 VGND VGND VPWR VPWR sky130_fd_sc_hd__fill_2
XFILLER_44_139 VGND VGND VPWR VPWR sky130_fd_sc_hd__fill_1
XFILLER_4_202 VGND VGND VPWR VPWR sky130_fd_sc_hd__decap_3
XFILLER_29_60 VGND VGND VPWR VPWR sky130_fd_sc_hd__fill_1
XFILLER_29_82 VGND VGND VPWR VPWR sky130_fd_sc_hd__fill_1
XFILLER_28_191 VGND VGND VPWR VPWR sky130_fd_sc_hd__decap_3
XFILLER_43_161 VGND VGND VPWR VPWR sky130_fd_sc_hd__fill_2
XFILLER_6_64 VGND VGND VPWR VPWR sky130_fd_sc_hd__decap_3
XFILLER_6_42 VGND VGND VPWR VPWR sky130_fd_sc_hd__fill_1
X_1007_ _1007_/A _1007_/B VGND VGND VPWR VPWR _1010_/D sky130_fd_sc_hd__nand2_2
Xrebuffer115 _0683_/B VGND VGND VPWR VPWR _0773_/A2 sky130_fd_sc_hd__buf_2
Xrebuffer104 _0914_/Y VGND VGND VPWR VPWR _0998_/A1 sky130_fd_sc_hd__buf_2
Xrebuffer159 _1171_/B VGND VGND VPWR VPWR _1254_/C1 sky130_fd_sc_hd__buf_2
Xrebuffer148 _0722_/Y VGND VGND VPWR VPWR _0726_/C1 sky130_fd_sc_hd__buf_6
XFILLER_17_128 VGND VGND VPWR VPWR sky130_fd_sc_hd__decap_3
XFILLER_25_161 VGND VGND VPWR VPWR sky130_fd_sc_hd__decap_3
XFILLER_32_109 VGND VGND VPWR VPWR sky130_fd_sc_hd__decap_3
XFILLER_40_197 VGND VGND VPWR VPWR sky130_fd_sc_hd__decap_3
Xoutput50 _1256_/Q VGND VGND VPWR VPWR psum_out[8] sky130_fd_sc_hd__clkdlybuf4s25_1
XFILLER_48_253 VGND VGND VPWR VPWR sky130_fd_sc_hd__decap_3
XFILLER_48_231 VGND VGND VPWR VPWR sky130_fd_sc_hd__decap_3
XFILLER_16_161 VGND VGND VPWR VPWR sky130_fd_sc_hd__decap_3
XFILLER_16_194 VGND VGND VPWR VPWR sky130_fd_sc_hd__fill_2
XFILLER_31_131 VGND VGND VPWR VPWR sky130_fd_sc_hd__fill_1
XFILLER_31_164 VGND VGND VPWR VPWR sky130_fd_sc_hd__decap_3
XFILLER_31_175 VGND VGND VPWR VPWR sky130_fd_sc_hd__fill_1
XFILLER_31_186 VGND VGND VPWR VPWR sky130_fd_sc_hd__decap_3
XFILLER_39_242 VGND VGND VPWR VPWR sky130_fd_sc_hd__decap_3
XFILLER_39_275 VGND VGND VPWR VPWR sky130_fd_sc_hd__decap_3
XFILLER_22_164 VGND VGND VPWR VPWR sky130_fd_sc_hd__decap_3
XFILLER_22_197 VGND VGND VPWR VPWR sky130_fd_sc_hd__decap_3
XFILLER_45_223 VGND VGND VPWR VPWR sky130_fd_sc_hd__fill_1
XFILLER_45_234 VGND VGND VPWR VPWR sky130_fd_sc_hd__decap_3
XFILLER_45_267 VGND VGND VPWR VPWR sky130_fd_sc_hd__decap_3
XFILLER_13_131 VGND VGND VPWR VPWR sky130_fd_sc_hd__decap_3
XFILLER_13_186 VGND VGND VPWR VPWR sky130_fd_sc_hd__decap_3
XFILLER_9_113 VGND VGND VPWR VPWR sky130_fd_sc_hd__fill_2
XFILLER_9_102 VGND VGND VPWR VPWR sky130_fd_sc_hd__decap_3
XFILLER_3_65 VGND VGND VPWR VPWR sky130_fd_sc_hd__decap_3
X_1272_ clkload0/A _1272_/D wire68/X VGND VGND VPWR VPWR _1272_/Q sky130_fd_sc_hd__dfrtp_2
XFILLER_36_256 VGND VGND VPWR VPWR sky130_fd_sc_hd__decap_3
X_0987_ _0987_/A _0991_/C _0991_/D _0987_/D VGND VGND VPWR VPWR _0988_/A sky130_fd_sc_hd__nand4_2
XFILLER_42_226 VGND VGND VPWR VPWR sky130_fd_sc_hd__decap_3
XFILLER_42_259 VGND VGND VPWR VPWR sky130_fd_sc_hd__decap_3
XFILLER_12_52 VGND VGND VPWR VPWR sky130_fd_sc_hd__decap_3
XFILLER_18_245 VGND VGND VPWR VPWR sky130_fd_sc_hd__decap_3
XFILLER_18_267 VGND VGND VPWR VPWR sky130_fd_sc_hd__decap_3
XFILLER_37_60 VGND VGND VPWR VPWR sky130_fd_sc_hd__fill_2
XPHY_EDGE_ROW_16_Right_16 VGND VGND VPWR VPWR sky130_fd_sc_hd__decap_3
XFILLER_41_270 VGND VGND VPWR VPWR sky130_fd_sc_hd__decap_3
XFILLER_41_281 VGND VGND VPWR VPWR sky130_fd_sc_hd__decap_3
X_0910_ _0905_/Y _0906_/X _0897_/X VGND VGND VPWR VPWR _0912_/C sky130_fd_sc_hd__o21ai_2
X_0841_ _0841_/A VGND VGND VPWR VPWR _0841_/Y sky130_fd_sc_hd__inv_2
X_0772_ _0772_/A _0841_/A VGND VGND VPWR VPWR _0774_/B sky130_fd_sc_hd__nand2_2
XTAP_TAPCELL_ROW_11_162 VGND VPWR sky130_fd_sc_hd__tapvpwrvgnd_1
XPHY_EDGE_ROW_25_Right_25 VGND VGND VPWR VPWR sky130_fd_sc_hd__decap_3
XFILLER_45_3 VGND VGND VPWR VPWR sky130_fd_sc_hd__decap_3
XFILLER_5_182 VGND VGND VPWR VPWR sky130_fd_sc_hd__decap_3
X_1186_ _1258_/Q _1276_/Q VGND VGND VPWR VPWR _1187_/B sky130_fd_sc_hd__and2_2
X_1255_ _1253_/X _1255_/A2 _1254_/Y wire55/X _1305_/Q VGND VGND VPWR VPWR _1305_/D
+ sky130_fd_sc_hd__a32o_2
XTAP_TAPCELL_ROW_3_119 VGND VPWR sky130_fd_sc_hd__tapvpwrvgnd_1
XPHY_EDGE_ROW_34_Right_34 VGND VGND VPWR VPWR sky130_fd_sc_hd__decap_3
XFILLER_24_215 VGND VGND VPWR VPWR sky130_fd_sc_hd__decap_3
XFILLER_24_259 VGND VGND VPWR VPWR sky130_fd_sc_hd__decap_3
XTAP_TAPCELL_ROW_34_276 VGND VPWR sky130_fd_sc_hd__tapvpwrvgnd_1
XPHY_EDGE_ROW_43_Right_43 VGND VGND VPWR VPWR sky130_fd_sc_hd__decap_3
XFILLER_15_215 VGND VGND VPWR VPWR sky130_fd_sc_hd__decap_3
XFILLER_15_259 VGND VGND VPWR VPWR sky130_fd_sc_hd__decap_3
XTAP_TAPCELL_ROW_25_232 VGND VPWR sky130_fd_sc_hd__tapvpwrvgnd_1
XFILLER_23_281 VGND VGND VPWR VPWR sky130_fd_sc_hd__decap_3
XFILLER_23_40 VGND VGND VPWR VPWR sky130_fd_sc_hd__decap_3
XFILLER_23_95 VGND VGND VPWR VPWR sky130_fd_sc_hd__decap_3
XFILLER_30_207 VGND VGND VPWR VPWR sky130_fd_sc_hd__decap_3
XFILLER_2_141 VGND VGND VPWR VPWR sky130_fd_sc_hd__decap_3
X_1040_ _1037_/Y _1038_/Y _1039_/Y VGND VGND VPWR VPWR _1082_/C sky130_fd_sc_hd__o21ai_2
XTAP_TAPCELL_ROW_48_346 VGND VPWR sky130_fd_sc_hd__tapvpwrvgnd_1
XFILLER_0_66 VGND VGND VPWR VPWR sky130_fd_sc_hd__fill_1
XFILLER_0_88 VGND VGND VPWR VPWR sky130_fd_sc_hd__decap_3
XFILLER_0_99 VGND VGND VPWR VPWR sky130_fd_sc_hd__decap_3
X_0824_ _0745_/A _0888_/A _0823_/Y _0821_/Y VGND VGND VPWR VPWR _0824_/Y sky130_fd_sc_hd__o211ai_4
X_0755_ _0755_/A _0755_/B _0755_/C VGND VGND VPWR VPWR _0771_/A sky130_fd_sc_hd__nand3_4
XFILLER_9_86 VGND VGND VPWR VPWR sky130_fd_sc_hd__decap_3
XFILLER_9_64 VGND VGND VPWR VPWR sky130_fd_sc_hd__decap_3
XFILLER_28_29 VGND VGND VPWR VPWR sky130_fd_sc_hd__decap_3
X_0686_ _0677_/X _0683_/X _0642_/D _0814_/A _0685_/Y VGND VGND VPWR VPWR _0687_/B
+ sky130_fd_sc_hd__o2111ai_4
XFILLER_44_39 VGND VGND VPWR VPWR sky130_fd_sc_hd__decap_3
X_1169_ _1304_/Q _1272_/Q VGND VGND VPWR VPWR _1250_/A sky130_fd_sc_hd__xor2_2
X_1238_ _1236_/X _1237_/X _1191_/Y _1238_/B1 wire55/A VGND VGND VPWR VPWR _1299_/D
+ sky130_fd_sc_hd__a32o_2
XTAP_TAPCELL_ROW_39_302 VGND VPWR sky130_fd_sc_hd__tapvpwrvgnd_1
XFILLER_20_240 VGND VGND VPWR VPWR sky130_fd_sc_hd__fill_2
XFILLER_20_262 VGND VGND VPWR VPWR sky130_fd_sc_hd__decap_3
XTAP_TAPCELL_ROW_22_213 VGND VPWR sky130_fd_sc_hd__tapvpwrvgnd_1
Xclkbuf_3_0__f_clk clkbuf_0_clk/X VGND VGND VPWR VPWR _1305_/CLK sky130_fd_sc_hd__clkbuf_16
XFILLER_18_62 VGND VGND VPWR VPWR sky130_fd_sc_hd__decap_3
XFILLER_11_240 VGND VGND VPWR VPWR sky130_fd_sc_hd__fill_2
XFILLER_11_284 VGND VGND VPWR VPWR sky130_fd_sc_hd__fill_2
XFILLER_7_255 VGND VGND VPWR VPWR sky130_fd_sc_hd__decap_3
X_1023_ _1023_/A _1023_/B _1070_/A _1023_/D VGND VGND VPWR VPWR _1023_/Y sky130_fd_sc_hd__nand4_2
X_0807_ split/A _0961_/C VGND VGND VPWR VPWR _0807_/X sky130_fd_sc_hd__and2_4
X_0738_ _1140_/A _0738_/B _0738_/C VGND VGND VPWR VPWR _1271_/D sky130_fd_sc_hd__and3_2
XFILLER_29_137 VGND VGND VPWR VPWR sky130_fd_sc_hd__decap_3
XFILLER_29_159 VGND VGND VPWR VPWR sky130_fd_sc_hd__decap_3
X_0669_ _1191_/A VGND VGND VPWR VPWR _1117_/A sky130_fd_sc_hd__clkbuf_2
XPHY_EDGE_ROW_2_Right_2 VGND VGND VPWR VPWR sky130_fd_sc_hd__decap_3
XFILLER_20_85 VGND VGND VPWR VPWR sky130_fd_sc_hd__decap_3
XFILLER_45_60 VGND VGND VPWR VPWR sky130_fd_sc_hd__decap_3
XFILLER_6_98 VGND VGND VPWR VPWR sky130_fd_sc_hd__decap_3
XFILLER_6_76 VGND VGND VPWR VPWR sky130_fd_sc_hd__decap_3
XFILLER_6_21 VGND VGND VPWR VPWR sky130_fd_sc_hd__decap_3
XFILLER_34_184 VGND VGND VPWR VPWR sky130_fd_sc_hd__decap_3
X_1006_ _1018_/B _1063_/A VGND VGND VPWR VPWR _1009_/A sky130_fd_sc_hd__nand2_2
Xrebuffer149 _0711_/Y VGND VGND VPWR VPWR _0717_/A1 sky130_fd_sc_hd__buf_2
Xrebuffer116 _0747_/Y VGND VGND VPWR VPWR _0829_/A2 sky130_fd_sc_hd__buf_2
Xrebuffer105 _0866_/Y VGND VGND VPWR VPWR _0871_/A2 sky130_fd_sc_hd__buf_2
XFILLER_1_228 VGND VGND VPWR VPWR sky130_fd_sc_hd__decap_3
XFILLER_9_9 VGND VGND VPWR VPWR sky130_fd_sc_hd__decap_3
XFILLER_15_85 VGND VGND VPWR VPWR sky130_fd_sc_hd__decap_3
XFILLER_31_84 VGND VGND VPWR VPWR sky130_fd_sc_hd__decap_3
Xoutput51 _1257_/Q VGND VGND VPWR VPWR psum_out[9] sky130_fd_sc_hd__clkdlybuf4s25_1
Xoutput40 _1263_/Q VGND VGND VPWR VPWR psum_out[15] sky130_fd_sc_hd__clkdlybuf4s25_1
XFILLER_48_221 VGND VGND VPWR VPWR sky130_fd_sc_hd__decap_3
XFILLER_48_265 VGND VGND VPWR VPWR sky130_fd_sc_hd__decap_3
XFILLER_36_29 VGND VGND VPWR VPWR sky130_fd_sc_hd__decap_3
XFILLER_39_210 VGND VGND VPWR VPWR sky130_fd_sc_hd__fill_2
XFILLER_39_254 VGND VGND VPWR VPWR sky130_fd_sc_hd__decap_3
XFILLER_22_121 VGND VGND VPWR VPWR sky130_fd_sc_hd__decap_3
XFILLER_22_176 VGND VGND VPWR VPWR sky130_fd_sc_hd__decap_3
XTAP_TAPCELL_ROW_17_190 VGND VPWR sky130_fd_sc_hd__tapvpwrvgnd_1
XFILLER_26_62 VGND VGND VPWR VPWR sky130_fd_sc_hd__decap_3
XFILLER_45_246 VGND VGND VPWR VPWR sky130_fd_sc_hd__decap_3
XFILLER_45_279 VGND VGND VPWR VPWR sky130_fd_sc_hd__fill_1
XFILLER_13_143 VGND VGND VPWR VPWR sky130_fd_sc_hd__decap_3
XFILLER_26_95 VGND VGND VPWR VPWR sky130_fd_sc_hd__fill_1
XFILLER_42_72 VGND VGND VPWR VPWR sky130_fd_sc_hd__decap_3
XFILLER_9_169 VGND VGND VPWR VPWR sky130_fd_sc_hd__decap_3
XFILLER_9_158 VGND VGND VPWR VPWR sky130_fd_sc_hd__decap_3
XFILLER_36_224 VGND VGND VPWR VPWR sky130_fd_sc_hd__decap_3
X_1271_ _1305_/CLK _1271_/D wire68/X VGND VGND VPWR VPWR _1271_/Q sky130_fd_sc_hd__dfrtp_2
XFILLER_36_268 VGND VGND VPWR VPWR sky130_fd_sc_hd__decap_3
X_0986_ _0903_/B _0777_/A _0977_/X _1035_/B _0972_/Y VGND VGND VPWR VPWR wire52/A
+ sky130_fd_sc_hd__o221ai_2
XFILLER_27_246 VGND VGND VPWR VPWR sky130_fd_sc_hd__decap_3
XFILLER_27_279 VGND VGND VPWR VPWR sky130_fd_sc_hd__fill_1
XFILLER_42_238 VGND VGND VPWR VPWR sky130_fd_sc_hd__decap_3
XFILLER_6_117 VGND VGND VPWR VPWR sky130_fd_sc_hd__decap_3
XFILLER_6_139 VGND VGND VPWR VPWR sky130_fd_sc_hd__fill_1
XFILLER_5_3 VGND VGND VPWR VPWR sky130_fd_sc_hd__decap_3
XFILLER_18_213 VGND VGND VPWR VPWR sky130_fd_sc_hd__decap_3
XFILLER_18_279 VGND VGND VPWR VPWR sky130_fd_sc_hd__decap_3
XFILLER_33_205 VGND VGND VPWR VPWR sky130_fd_sc_hd__fill_2
XFILLER_37_83 VGND VGND VPWR VPWR sky130_fd_sc_hd__decap_3
X_0840_ _0828_/Y _0835_/Y _0839_/Y VGND VGND VPWR VPWR _0843_/A sky130_fd_sc_hd__o21ai_4
X_0771_ _0771_/A _0771_/B VGND VGND VPWR VPWR _0772_/A sky130_fd_sc_hd__nand2_2
XFILLER_38_3 VGND VGND VPWR VPWR sky130_fd_sc_hd__decap_3
X_1185_ _1258_/Q _1276_/Q VGND VGND VPWR VPWR _1187_/A sky130_fd_sc_hd__nor2_2
X_1254_ _1150_/X _1252_/Y _1171_/C _1254_/C1 VGND VGND VPWR VPWR _1254_/Y sky130_fd_sc_hd__o211ai_2
XFILLER_32_271 VGND VGND VPWR VPWR sky130_fd_sc_hd__decap_3
XTAP_TAPCELL_ROW_34_277 VGND VPWR sky130_fd_sc_hd__tapvpwrvgnd_1
X_0969_ _0960_/Y _0961_/Y _0890_/A _0889_/Y VGND VGND VPWR VPWR _0970_/B sky130_fd_sc_hd__o2bb2ai_2
XFILLER_15_238 VGND VGND VPWR VPWR sky130_fd_sc_hd__decap_3
XFILLER_23_271 VGND VGND VPWR VPWR sky130_fd_sc_hd__decap_3
XFILLER_23_52 VGND VGND VPWR VPWR sky130_fd_sc_hd__decap_3
XFILLER_23_63 VGND VGND VPWR VPWR sky130_fd_sc_hd__decap_3
XFILLER_2_197 VGND VGND VPWR VPWR sky130_fd_sc_hd__decap_3
XFILLER_24_9 VGND VGND VPWR VPWR sky130_fd_sc_hd__decap_3
XTAP_TAPCELL_ROW_48_347 VGND VPWR sky130_fd_sc_hd__tapvpwrvgnd_1
XFILLER_48_71 VGND VGND VPWR VPWR sky130_fd_sc_hd__decap_3
XTAP_TAPCELL_ROW_31_258 VGND VPWR sky130_fd_sc_hd__tapvpwrvgnd_1
XFILLER_9_76 VGND VGND VPWR VPWR sky130_fd_sc_hd__fill_1
XFILLER_9_43 VGND VGND VPWR VPWR sky130_fd_sc_hd__decap_3
XFILLER_9_32 VGND VGND VPWR VPWR sky130_fd_sc_hd__fill_1
X_0823_ _0811_/Y _0810_/Y _0805_/Y _0822_/Y VGND VGND VPWR VPWR _0823_/Y sky130_fd_sc_hd__o2bb2ai_4
X_0754_ _0680_/B _0745_/A _0757_/C _0757_/B VGND VGND VPWR VPWR _0755_/C sky130_fd_sc_hd__o211ai_4
X_0685_ _0683_/X _0684_/Y _0685_/B1 VGND VGND VPWR VPWR _0685_/Y sky130_fd_sc_hd__o21ai_4
XFILLER_44_18 VGND VGND VPWR VPWR sky130_fd_sc_hd__decap_3
XFILLER_44_29 VGND VGND VPWR VPWR sky130_fd_sc_hd__fill_1
X_1099_ _1067_/A _0900_/A _1098_/X _1022_/X VGND VGND VPWR VPWR _1099_/X sky130_fd_sc_hd__a31o_2
X_1168_ _1165_/Y _1247_/B _1247_/A VGND VGND VPWR VPWR _1250_/C sky130_fd_sc_hd__a21oi_4
X_1237_ _1236_/C _1236_/B _1298_/Q _1266_/Q VGND VGND VPWR VPWR _1237_/X sky130_fd_sc_hd__a2bb2o_2
XTAP_TAPCELL_ROW_22_214 VGND VPWR sky130_fd_sc_hd__tapvpwrvgnd_1
XPHY_EDGE_ROW_8_Left_57 VGND VGND VPWR VPWR sky130_fd_sc_hd__decap_3
XFILLER_18_41 VGND VGND VPWR VPWR sky130_fd_sc_hd__decap_3
XFILLER_18_85 VGND VGND VPWR VPWR sky130_fd_sc_hd__decap_3
XFILLER_47_116 VGND VGND VPWR VPWR sky130_fd_sc_hd__fill_1
XFILLER_47_149 VGND VGND VPWR VPWR sky130_fd_sc_hd__decap_3
XTAP_TAPCELL_ROW_45_328 VGND VPWR sky130_fd_sc_hd__tapvpwrvgnd_1
XFILLER_7_267 VGND VGND VPWR VPWR sky130_fd_sc_hd__fill_2
XFILLER_7_223 VGND VGND VPWR VPWR sky130_fd_sc_hd__fill_1
XFILLER_22_6 VGND VGND VPWR VPWR sky130_fd_sc_hd__fill_2
XFILLER_38_127 VGND VGND VPWR VPWR sky130_fd_sc_hd__decap_3
XFILLER_46_193 VGND VGND VPWR VPWR sky130_fd_sc_hd__decap_3
X_1022_ _1029_/C _1027_/A _1070_/A _1119_/D VGND VGND VPWR VPWR _1022_/X sky130_fd_sc_hd__and4_4
X_0806_ _0894_/B VGND VGND VPWR VPWR _1104_/C sky130_fd_sc_hd__buf_6
X_0737_ _0702_/X _0697_/X _0801_/A _0735_/Y _0703_/X VGND VGND VPWR VPWR _0738_/C
+ sky130_fd_sc_hd__a221o_2
X_0668_ _0668_/A _0668_/B VGND VGND VPWR VPWR _0668_/Y sky130_fd_sc_hd__nor2_2
XFILLER_29_116 VGND VGND VPWR VPWR sky130_fd_sc_hd__decap_3
XFILLER_37_160 VGND VGND VPWR VPWR sky130_fd_sc_hd__decap_3
XFILLER_37_193 VGND VGND VPWR VPWR sky130_fd_sc_hd__decap_3
XFILLER_20_42 VGND VGND VPWR VPWR sky130_fd_sc_hd__decap_3
XFILLER_20_75 VGND VGND VPWR VPWR sky130_fd_sc_hd__decap_3
XFILLER_20_97 VGND VGND VPWR VPWR sky130_fd_sc_hd__decap_3
XFILLER_35_108 VGND VGND VPWR VPWR sky130_fd_sc_hd__decap_3
XFILLER_43_152 VGND VGND VPWR VPWR sky130_fd_sc_hd__decap_3
XFILLER_3_281 VGND VGND VPWR VPWR sky130_fd_sc_hd__decap_3
XFILLER_34_141 VGND VGND VPWR VPWR sky130_fd_sc_hd__fill_1
X_1005_ _1002_/X _1005_/B _1005_/C VGND VGND VPWR VPWR _1063_/A sky130_fd_sc_hd__nand3b_4
Xrebuffer117 _0747_/Y VGND VGND VPWR VPWR _0751_/A2 sky130_fd_sc_hd__buf_2
Xrebuffer106 _0856_/Y VGND VGND VPWR VPWR _0934_/A2_N sky130_fd_sc_hd__buf_4
XFILLER_17_119 VGND VGND VPWR VPWR sky130_fd_sc_hd__decap_3
XFILLER_25_196 VGND VGND VPWR VPWR sky130_fd_sc_hd__decap_3
XFILLER_40_155 VGND VGND VPWR VPWR sky130_fd_sc_hd__decap_3
XFILLER_40_177 VGND VGND VPWR VPWR sky130_fd_sc_hd__decap_3
XFILLER_40_188 VGND VGND VPWR VPWR sky130_fd_sc_hd__fill_1
XFILLER_31_96 VGND VGND VPWR VPWR sky130_fd_sc_hd__decap_3
Xoutput41 _1264_/Q VGND VGND VPWR VPWR psum_out[16] sky130_fd_sc_hd__clkdlybuf4s25_1
Xoutput30 _1294_/Q VGND VGND VPWR VPWR b_out[4] sky130_fd_sc_hd__clkdlybuf4s25_1
XFILLER_0_284 VGND VGND VPWR VPWR sky130_fd_sc_hd__fill_2
XFILLER_48_277 VGND VGND VPWR VPWR sky130_fd_sc_hd__decap_3
XFILLER_48_244 VGND VGND VPWR VPWR sky130_fd_sc_hd__decap_3
XFILLER_48_200 VGND VGND VPWR VPWR sky130_fd_sc_hd__decap_3
XFILLER_16_185 VGND VGND VPWR VPWR sky130_fd_sc_hd__decap_3
XFILLER_31_111 VGND VGND VPWR VPWR sky130_fd_sc_hd__fill_1
XFILLER_31_122 VGND VGND VPWR VPWR sky130_fd_sc_hd__decap_3
XFILLER_31_155 VGND VGND VPWR VPWR sky130_fd_sc_hd__decap_3
.ends
